* Spice description of oa2a22_x2
* Spice driver version 889478061
* Date ( dd/mm/yyyy hh:mm:ss ):  8/05/2026 at 14:23:17

* INTERF i0 i1 i2 i3 q vdd vss

.subckt oa2a22_x2 33 27 40 46 23 19 71
* NET 19 = vdd
* NET 23 = q
* NET 27 = i1
* NET 33 = i0
* NET 40 = i2
* NET 46 = i3
* NET 71 = vss
Mtr_00010 62 36 1 19 sky130_fd_pr__pfet_01v8__model L=0.15U W=1.5U AS=0.435P AD=0.435P PS=3.58U PD=3.58U
Mtr_00009 14 47 2 19 sky130_fd_pr__pfet_01v8__model L=0.15U W=1.5U AS=0.435P AD=0.435P PS=3.58U PD=3.58U
Mtr_00008 3 42 14 19 sky130_fd_pr__pfet_01v8__model L=0.15U W=1.5U AS=0.435P AD=0.435P PS=3.58U PD=3.58U
Mtr_00007 2 30 62 19 sky130_fd_pr__pfet_01v8__model L=0.15U W=1.5U AS=0.435P AD=0.435P PS=3.58U PD=3.58U
Mtr_00006 24 61 12 19 sky130_fd_pr__pfet_01v8__model L=0.15U W=2.46U AS=0.7134P AD=0.7134P PS=5.5U PD=5.5U
Mtr_00005 51 39 74 71 sky130_fd_pr__nfet_01v8__model L=0.15U W=0.78U AS=0.2262P AD=0.2262P PS=2.14U PD=2.14U
Mtr_00004 54 45 51 71 sky130_fd_pr__nfet_01v8__model L=0.15U W=0.78U AS=0.2262P AD=0.2262P PS=2.14U PD=2.14U
Mtr_00003 68 28 54 71 sky130_fd_pr__nfet_01v8__model L=0.15U W=0.78U AS=0.2262P AD=0.2262P PS=2.14U PD=2.14U
Mtr_00002 72 34 68 71 sky130_fd_pr__nfet_01v8__model L=0.15U W=0.78U AS=0.2262P AD=0.2262P PS=2.14U PD=2.14U
Mtr_00001 76 58 22 71 sky130_fd_pr__nfet_01v8__model L=0.15U W=1.26U AS=0.3654P AD=0.3654P PS=3.1U PD=3.1U
R11_1 3 9 15
R11_2 3 6 15
R11_3 5 2 15
R11_4 8 2 15
R11_5 7 1 15
R11_6 4 1 15
R11_7 4 7 13
C11_71 4 71 5.3574e-17
C11_72 7 71 5.3574e-17
R11_8 7 8 52
C11_81 7 71 1.28578e-16
C11_82 8 71 1.28578e-16
R11_9 5 8 13
C11_91 5 71 5.3574e-17
C11_92 8 71 5.3574e-17
R11_10 5 6 52
C11_101 5 71 1.28578e-16
C11_102 6 71 1.28578e-16
R11_11 6 9 13
C11_111 6 71 5.3574e-17
C11_112 9 71 5.3574e-17
R10_1 12 13 15
R10_2 15 12 15
R10_3 18 12 15
R10_4 16 12 15
R10_5 17 14 15
R10_6 17 19 26
C10_61 17 71 6.42888e-17
C10_62 19 71 6.42888e-17
R10_7 18 19 26
C10_71 18 71 6.42888e-17
C10_72 19 71 6.42888e-17
R10_8 16 18 26
C10_81 16 71 6.42888e-17
C10_82 18 71 6.42888e-17
R10_9 15 16 26
C10_91 15 71 6.42888e-17
C10_92 16 71 6.42888e-17
R10_10 13 15 13
C10_101 13 71 5.3574e-17
C10_102 15 71 5.3574e-17
R9_1 23 22 7.5
R9_2 23 24 3.75
R8_1 29 27 15
R8_2 29 30 672
C8_21 29 71 1.19192e-16
C8_22 30 71 1.19192e-16
R8_3 28 29 480
C8_31 28 71 8.69778e-17
C8_32 29 71 8.69778e-17
R7_1 35 33 15
R7_2 35 36 672
C7_21 35 71 1.19192e-16
C7_22 36 71 1.19192e-16
R7_3 34 35 480
C7_31 34 71 8.69778e-17
C7_32 35 71 8.69778e-17
R6_1 41 40 15
R6_2 41 42 672
C6_21 41 71 1.19192e-16
C6_22 42 71 1.19192e-16
R6_3 39 41 480
C6_31 39 71 8.69778e-17
C6_32 41 71 8.69778e-17
R5_1 48 46 15
R5_2 48 47 672
C5_21 48 71 1.19192e-16
C5_22 47 71 1.19192e-16
R5_3 45 48 480
C5_31 45 71 8.69778e-17
C5_32 48 71 8.69778e-17
R3_1 55 54 15
R3_2 64 62 15
R3_3 60 59 15
R3_4 60 61 528
C3_41 60 71 9.34206e-17
C3_42 61 71 9.34206e-17
R3_5 58 60 432
C3_51 58 71 7.40922e-17
C3_52 60 71 7.40922e-17
R3_6 57 59 39
C3_61 57 71 1.07148e-16
C3_62 59 71 1.07148e-16
R3_7 63 64 13
C3_71 63 71 5.3574e-17
C3_72 64 71 5.3574e-17
R3_8 56 57 65
C3_81 56 71 1.60722e-16
C3_82 57 71 1.60722e-16
R3_9 63 65 26
C3_91 63 71 6.42888e-17
C3_92 65 71 6.42888e-17
R3_10 56 65 104
C3_101 56 71 2.4644e-16
C3_102 65 71 2.4644e-16
R3_11 55 56 13
C3_111 55 71 5.3574e-17
C3_112 56 71 5.3574e-17
R1_1 73 72 15
R1_2 77 76 15
R1_3 78 76 15
R1_4 75 74 15
R1_5 71 75 26
C1_51 71 71 6.42888e-17
C1_52 75 71 6.42888e-17
R1_6 77 78 26
C1_61 77 71 7.50036e-17
C1_62 78 71 7.50036e-17
R1_7 71 77 26
C1_71 71 71 6.42888e-17
C1_72 77 71 6.42888e-17
R1_8 71 73 26
C1_81 71 71 6.42888e-17
C1_82 73 71 6.42888e-17
.ends oa2a22_x2
