* Spice description of o3_x4
* Spice driver version 1497037741
* Date ( dd/mm/yyyy hh:mm:ss ):  8/05/2026 at 14:23:17

* INTERF i0 i1 i2 q vdd vss

.subckt o3_x4 14 1 7 40 30 44
* NET 1 = i1
* NET 7 = i2
* NET 14 = i0
* NET 30 = vdd
* NET 40 = q
* NET 44 = vss
Mtr_00010 33 4 36 30 sky130_fd_pr__pfet_01v8__model L=0.15U W=2.46U AS=0.7134P AD=0.7134P PS=5.5U PD=5.5U
Mtr_00009 65 10 36 30 sky130_fd_pr__pfet_01v8__model L=0.15U W=2.46U AS=0.7134P AD=0.7134P PS=5.5U PD=5.5U
Mtr_00008 20 17 33 30 sky130_fd_pr__pfet_01v8__model L=0.15U W=2.46U AS=0.7134P AD=0.7134P PS=5.5U PD=5.5U
Mtr_00007 22 64 41 30 sky130_fd_pr__pfet_01v8__model L=0.15U W=2.46U AS=0.7134P AD=0.7134P PS=5.5U PD=5.5U
Mtr_00006 41 63 20 30 sky130_fd_pr__pfet_01v8__model L=0.15U W=2.46U AS=0.7134P AD=0.7134P PS=5.5U PD=5.5U
Mtr_00005 45 3 57 44 sky130_fd_pr__nfet_01v8__model L=0.15U W=0.66U AS=0.1914P AD=0.1914P PS=1.9U PD=1.9U
Mtr_00004 45 9 54 44 sky130_fd_pr__nfet_01v8__model L=0.15U W=0.66U AS=0.1914P AD=0.1914P PS=1.9U PD=1.9U
Mtr_00003 49 60 39 44 sky130_fd_pr__nfet_01v8__model L=0.15U W=1.26U AS=0.3654P AD=0.3654P PS=3.1U PD=3.1U
Mtr_00002 39 60 47 44 sky130_fd_pr__nfet_01v8__model L=0.15U W=1.26U AS=0.3654P AD=0.3654P PS=3.1U PD=3.1U
Mtr_00001 57 16 47 44 sky130_fd_pr__nfet_01v8__model L=0.15U W=0.66U AS=0.1914P AD=0.1914P PS=1.9U PD=1.9U
R9_1 2 1 15
R9_2 2 4 672
C9_21 2 44 1.16776e-16
C9_22 4 44 1.16776e-16
R9_3 3 2 384
C9_31 3 44 6.4428e-17
C9_32 2 44 6.4428e-17
R8_1 8 7 15
R8_2 11 10 48
C8_21 11 44 1.28856e-17
C8_22 10 44 1.28856e-17
R8_3 8 11 240
C8_31 8 44 4.50996e-17
C8_32 11 44 4.50996e-17
R8_4 9 8 384
C8_41 9 44 6.4428e-17
C8_42 8 44 6.4428e-17
R7_1 15 14 15
R7_2 15 17 672
C7_21 15 44 1.19192e-16
C7_22 17 44 1.19192e-16
R7_3 16 15 384
C7_31 16 44 6.4428e-17
C7_32 15 44 6.4428e-17
R6_1 20 21 15
R6_2 24 20 15
R6_3 26 20 15
R6_4 28 20 15
R6_5 29 22 15
R6_6 27 22 15
R6_7 25 22 15
R6_8 23 22 15
R6_9 29 30 26
C6_91 29 44 6.42888e-17
C6_92 30 44 6.42888e-17
R6_10 27 29 13
C6_101 27 44 5.3574e-17
C6_102 29 44 5.3574e-17
R6_11 25 27 26
C6_111 25 44 6.42888e-17
C6_112 27 44 6.42888e-17
R6_12 23 25 26
C6_121 23 44 6.42888e-17
C6_122 25 44 6.42888e-17
R6_13 28 30 26
C6_131 28 44 6.42888e-17
C6_132 30 44 6.42888e-17
R6_14 26 28 13
C6_141 26 44 5.3574e-17
C6_142 28 44 5.3574e-17
R6_15 24 26 26
C6_151 24 44 6.42888e-17
C6_152 26 44 6.42888e-17
R6_16 21 24 26
C6_161 21 44 6.42888e-17
C6_162 24 44 6.42888e-17
R3_1 40 39 7.5
R3_2 40 41 3.75
R2_1 48 47 7.5
R2_2 51 49 15
R2_3 50 49 15
R2_4 46 45 15
R2_5 44 46 26
C2_51 44 44 6.42888e-17
C2_52 46 44 6.42888e-17
R2_6 50 51 26
C2_61 50 44 6.42888e-17
C2_62 51 44 6.42888e-17
R2_7 44 50 26
C2_71 44 44 6.42888e-17
C2_72 50 44 6.42888e-17
R2_8 44 48 26
C2_81 44 44 6.42888e-17
C2_82 48 44 6.42888e-17
R1_1 58 57 15
R1_2 56 54 15
R1_3 69 65 15
R1_4 66 65 15
R1_5 68 65 15
R1_6 67 65 15
R1_7 60 62 15
R1_8 60 63 912
C1_81 60 44 1.59459e-16
C1_82 63 44 1.59459e-16
R1_9 60 64 912
C1_91 60 44 1.59459e-16
C1_92 64 44 1.59459e-16
R1_10 61 62 26
C1_101 61 44 6.42888e-17
C1_102 62 44 6.42888e-17
R1_11 68 69 13
C1_111 68 44 5.3574e-17
C1_112 69 44 5.3574e-17
R1_12 66 68 26
C1_121 66 44 6.42888e-17
C1_122 68 44 6.42888e-17
R1_13 67 66 26
C1_131 67 44 6.42888e-17
C1_132 66 44 6.42888e-17
R1_14 55 67 65
C1_141 55 44 1.71437e-16
C1_142 67 44 1.71437e-16
R1_15 56 55 13
C1_151 56 44 5.3574e-17
C1_152 55 44 5.3574e-17
R1_16 59 61 26
C1_161 59 44 7.50036e-17
C1_162 61 44 7.50036e-17
R1_17 55 59 52
C1_171 55 44 1.17863e-16
C1_172 59 44 1.17863e-16
R1_18 58 59 13
C1_181 58 44 5.3574e-17
C1_182 59 44 5.3574e-17
.ends o3_x4
