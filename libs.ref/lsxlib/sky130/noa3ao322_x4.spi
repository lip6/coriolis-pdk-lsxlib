* Spice description of noa3ao322_x4
* Spice driver version -10904659
* Date ( dd/mm/yyyy hh:mm:ss ):  8/05/2026 at 14:22:51

* INTERF i0 i1 i2 i3 i4 i5 i6 nq vdd vss

.subckt noa3ao322_x4 82 58 1 8 19 26 14 98 94 102
* NET 1 = i2
* NET 8 = i3
* NET 14 = i6
* NET 19 = i4
* NET 26 = i5
* NET 58 = i1
* NET 82 = i0
* NET 94 = vdd
* NET 98 = nq
* NET 102 = vss
Mtr_00020 34 27 37 94 sky130_fd_pr__pfet_01v8__model L=0.15U W=2.46U AS=0.7134P AD=0.7134P PS=5.5U PD=5.5U
Mtr_00019 99 122 88 94 sky130_fd_pr__pfet_01v8__model L=0.15U W=2.46U AS=0.7134P AD=0.7134P PS=5.5U PD=5.5U
Mtr_00018 99 123 89 94 sky130_fd_pr__pfet_01v8__model L=0.15U W=2.46U AS=0.7134P AD=0.7134P PS=5.5U PD=5.5U
Mtr_00017 89 85 38 94 sky130_fd_pr__pfet_01v8__model L=0.15U W=1.5U AS=0.435P AD=0.435P PS=3.58U PD=3.58U
Mtr_00016 38 61 90 94 sky130_fd_pr__pfet_01v8__model L=0.15U W=1.5U AS=0.435P AD=0.435P PS=3.58U PD=3.58U
Mtr_00015 90 4 39 94 sky130_fd_pr__pfet_01v8__model L=0.15U W=1.5U AS=0.435P AD=0.435P PS=3.58U PD=3.58U
Mtr_00014 124 75 88 94 sky130_fd_pr__pfet_01v8__model L=0.15U W=1.26U AS=0.3654P AD=0.3654P PS=3.1U PD=3.1U
Mtr_00013 39 16 72 94 sky130_fd_pr__pfet_01v8__model L=0.15U W=1.5U AS=0.435P AD=0.435P PS=3.58U PD=3.58U
Mtr_00012 31 9 72 94 sky130_fd_pr__pfet_01v8__model L=0.15U W=2.46U AS=0.7134P AD=0.7134P PS=5.5U PD=5.5U
Mtr_00011 34 21 31 94 sky130_fd_pr__pfet_01v8__model L=0.15U W=2.46U AS=0.7134P AD=0.7134P PS=5.5U PD=5.5U
Mtr_00010 109 25 52 102 sky130_fd_pr__nfet_01v8__model L=0.15U W=0.54U AS=0.1566P AD=0.1566P PS=1.66U PD=1.66U
Mtr_00009 65 2 47 102 sky130_fd_pr__nfet_01v8__model L=0.15U W=1.14U AS=0.3306P AD=0.3306P PS=2.86U PD=2.86U
Mtr_00008 50 13 65 102 sky130_fd_pr__nfet_01v8__model L=0.15U W=0.54U AS=0.1566P AD=0.1566P PS=1.66U PD=1.66U
Mtr_00007 107 7 50 102 sky130_fd_pr__nfet_01v8__model L=0.15U W=0.54U AS=0.1566P AD=0.1566P PS=1.66U PD=1.66U
Mtr_00006 52 20 107 102 sky130_fd_pr__nfet_01v8__model L=0.15U W=0.54U AS=0.1566P AD=0.1566P PS=1.66U PD=1.66U
Mtr_00005 47 59 114 102 sky130_fd_pr__nfet_01v8__model L=0.15U W=1.14U AS=0.3306P AD=0.3306P PS=2.86U PD=2.86U
Mtr_00004 114 83 105 102 sky130_fd_pr__nfet_01v8__model L=0.15U W=1.14U AS=0.3306P AD=0.3306P PS=2.86U PD=2.86U
Mtr_00003 103 64 117 102 sky130_fd_pr__nfet_01v8__model L=0.15U W=0.66U AS=0.1914P AD=0.1914P PS=1.9U PD=1.9U
Mtr_00002 97 119 103 102 sky130_fd_pr__nfet_01v8__model L=0.15U W=1.26U AS=0.3654P AD=0.3654P PS=3.1U PD=3.1U
Mtr_00001 105 119 97 102 sky130_fd_pr__nfet_01v8__model L=0.15U W=1.26U AS=0.3654P AD=0.3654P PS=3.1U PD=3.1U
R18_1 3 1 15
R18_2 3 4 672
C18_21 3 102 1.19192e-16
C18_22 4 102 1.19192e-16
R18_3 2 3 432
C18_31 2 102 7.73136e-17
C18_32 3 102 7.73136e-17
R17_1 10 8 15
R17_2 10 9 528
C17_21 10 102 9.34206e-17
C17_22 9 102 9.34206e-17
R17_3 7 10 528
C17_31 7 102 9.10046e-17
C17_32 10 102 9.10046e-17
R16_1 15 14 15
R16_2 15 16 672
C16_21 15 102 1.19192e-16
C16_22 16 102 1.19192e-16
R16_3 13 15 528
C16_31 13 102 9.10046e-17
C16_32 15 102 9.10046e-17
R15_1 22 19 15
R15_2 22 21 528
C15_21 22 102 9.34206e-17
C15_22 21 102 9.34206e-17
R15_3 20 22 528
C15_31 20 102 9.10046e-17
C15_32 22 102 9.10046e-17
R14_1 28 26 15
R14_2 28 27 528
C14_21 28 102 9.34206e-17
C14_22 27 102 9.34206e-17
R14_3 25 28 528
C14_31 25 102 9.34206e-17
C14_32 28 102 9.34206e-17
R11_1 44 37 15
R11_2 43 39 15
R11_3 42 38 15
R11_4 40 42 13
C11_41 40 102 5.3574e-17
C11_42 42 102 5.3574e-17
R11_5 40 41 52
C11_51 40 102 1.28578e-16
C11_52 41 102 1.28578e-16
R11_6 41 43 13
C11_61 41 102 5.3574e-17
C11_62 43 102 5.3574e-17
R11_7 43 44 104
C11_71 43 102 2.4644e-16
C11_72 44 102 2.4644e-16
R9_1 51 50 15
R9_2 53 52 7.5
R9_3 53 55 13
C9_31 53 102 5.3574e-17
C9_32 55 102 5.3574e-17
R9_4 54 55 52
C9_41 54 102 1.28578e-16
C9_42 55 102 1.28578e-16
R9_5 51 54 13
C9_51 51 102 5.3574e-17
C9_52 54 102 5.3574e-17
R8_1 60 58 15
R8_2 60 61 672
C8_21 60 102 1.19192e-16
C8_22 61 102 1.19192e-16
R8_3 59 60 432
C8_31 59 102 7.73136e-17
C8_32 60 102 7.73136e-17
R7_1 71 70 15
R7_2 73 72 15
R7_3 79 72 15
R7_4 74 72 15
R7_5 68 65 15
R7_6 66 65 15
R7_7 68 67 13
C7_71 68 102 4.28592e-17
C7_72 67 102 4.28592e-17
R7_8 66 68 26
C7_81 66 102 6.42888e-17
C7_82 68 102 6.42888e-17
R7_9 67 69 26
C7_91 67 102 7.50036e-17
C7_92 69 102 7.50036e-17
R7_10 73 79 26
C7_101 73 102 5.89314e-17
C7_102 79 102 5.89314e-17
R7_11 74 73 26
C7_111 74 102 6.96462e-17
C7_112 73 102 6.96462e-17
R7_12 69 74 52
C7_121 69 102 1.17863e-16
C7_122 74 102 1.17863e-16
R7_13 78 73 104
C7_131 78 102 2.57155e-16
C7_132 73 102 2.57155e-16
R7_14 78 77 13
C7_141 78 102 5.3574e-17
C7_142 77 102 5.3574e-17
R7_15 76 77 52
C7_151 76 102 1.28578e-16
C7_152 77 102 1.28578e-16
R7_16 70 76 65
C7_161 70 102 1.71437e-16
C7_162 76 102 1.71437e-16
R7_17 71 75 672
C7_171 71 102 1.12749e-16
C7_172 75 102 1.12749e-16
R7_18 64 71 576
C7_181 64 102 1.03085e-16
C7_182 71 102 1.03085e-16
R6_1 84 82 15
R6_2 84 85 672
C6_21 84 102 1.19192e-16
C6_22 85 102 1.19192e-16
R6_3 83 84 432
C6_31 83 102 7.73136e-17
C6_32 84 102 7.73136e-17
R5_1 91 88 15
R5_2 93 90 15
R5_3 92 89 15
R5_4 92 94 26
C5_41 92 102 6.42888e-17
C5_42 94 102 6.42888e-17
R5_5 93 94 26
C5_51 93 102 6.42888e-17
C5_52 94 102 6.42888e-17
R5_6 91 94 26
C5_61 91 102 6.42888e-17
C5_62 94 102 6.42888e-17
R4_1 98 97 7.5
R4_2 98 99 7.5
R3_1 106 105 15
R3_2 110 109 15
R3_3 108 107 15
R3_4 104 103 15
R3_5 111 103 15
R3_6 104 111 26
C3_61 104 102 6.42888e-17
C3_62 111 102 6.42888e-17
R3_7 102 104 26
C3_71 102 102 6.42888e-17
C3_72 104 102 6.42888e-17
R3_8 102 108 26
C3_81 102 102 6.42888e-17
C3_82 108 102 6.42888e-17
R3_9 102 110 26
C3_91 102 102 6.42888e-17
C3_92 110 102 6.42888e-17
R3_10 102 106 26
C3_101 102 102 6.42888e-17
C3_102 106 102 6.42888e-17
R1_1 118 117 15
R1_2 125 124 15
R1_3 126 124 15
R1_4 119 121 15
R1_5 119 122 912
C1_51 119 102 1.59459e-16
C1_52 122 102 1.59459e-16
R1_6 119 123 912
C1_61 119 102 1.59459e-16
C1_62 123 102 1.59459e-16
R1_7 120 121 26
C1_71 120 102 7.50036e-17
C1_72 121 102 7.50036e-17
R1_8 125 126 26
C1_81 125 102 7.50036e-17
C1_82 126 102 7.50036e-17
R1_9 120 125 91
C1_91 120 102 2.14296e-16
C1_92 125 102 2.14296e-16
R1_10 118 120 52
C1_101 118 102 1.17863e-16
C1_102 120 102 1.17863e-16
.ends noa3ao322_x4
