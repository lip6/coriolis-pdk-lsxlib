* Spice description of noa2a22_x1
* Spice driver version 1095707565
* Date ( dd/mm/yyyy hh:mm:ss ):  8/05/2026 at 14:22:51

* INTERF i0 i1 i2 i3 nq vdd vss

.subckt noa2a22_x1 19 13 9 2 45 38 51
* NET 2 = i3
* NET 9 = i2
* NET 13 = i1
* NET 19 = i0
* NET 38 = vdd
* NET 45 = nq
* NET 51 = vss
Mtr_00008 36 3 26 38 sky130_fd_pr__pfet_01v8__model L=0.15U W=2.46U AS=0.7134P AD=0.7134P PS=5.5U PD=5.5U
Mtr_00007 27 7 36 38 sky130_fd_pr__pfet_01v8__model L=0.15U W=2.46U AS=0.7134P AD=0.7134P PS=5.5U PD=5.5U
Mtr_00006 26 16 46 38 sky130_fd_pr__pfet_01v8__model L=0.15U W=2.46U AS=0.7134P AD=0.7134P PS=5.5U PD=5.5U
Mtr_00005 46 22 25 38 sky130_fd_pr__pfet_01v8__model L=0.15U W=2.46U AS=0.7134P AD=0.7134P PS=5.5U PD=5.5U
Mtr_00004 41 8 53 51 sky130_fd_pr__nfet_01v8__model L=0.15U W=1.26U AS=0.3654P AD=0.3654P PS=3.1U PD=3.1U
Mtr_00003 44 1 41 51 sky130_fd_pr__nfet_01v8__model L=0.15U W=1.26U AS=0.3654P AD=0.3654P PS=3.1U PD=3.1U
Mtr_00002 58 14 44 51 sky130_fd_pr__nfet_01v8__model L=0.15U W=1.26U AS=0.3654P AD=0.3654P PS=3.1U PD=3.1U
Mtr_00001 52 20 58 51 sky130_fd_pr__nfet_01v8__model L=0.15U W=1.26U AS=0.3654P AD=0.3654P PS=3.1U PD=3.1U
R10_1 4 2 15
R10_2 4 3 528
C10_21 4 51 9.34206e-17
C10_22 3 51 9.34206e-17
R10_3 1 4 432
C10_31 1 51 7.40922e-17
C10_32 4 51 7.40922e-17
R9_1 10 9 15
R9_2 10 7 528
C9_21 10 51 9.34206e-17
C9_22 7 51 9.34206e-17
R9_3 8 10 432
C9_31 8 51 7.40922e-17
C9_32 10 51 7.40922e-17
R8_1 15 13 15
R8_2 15 16 528
C8_21 15 51 9.34206e-17
C8_22 16 51 9.34206e-17
R8_3 14 15 432
C8_31 14 51 7.40922e-17
C8_32 15 51 7.40922e-17
R7_1 21 19 15
R7_2 21 22 528
C7_21 21 51 9.34206e-17
C7_22 22 51 9.34206e-17
R7_3 20 21 432
C7_31 20 51 7.40922e-17
C7_32 21 51 7.40922e-17
R6_1 32 26 15
R6_2 29 26 15
R6_3 31 25 15
R6_4 30 27 15
R6_5 28 25 15
R6_6 33 27 15
R6_7 30 33 13
C6_71 30 51 5.3574e-17
C6_72 33 51 5.3574e-17
R6_8 28 31 13
C6_81 28 51 5.3574e-17
C6_82 31 51 5.3574e-17
R6_9 29 30 52
C6_91 29 51 1.28578e-16
C6_92 30 51 1.28578e-16
R6_10 29 32 13
C6_101 29 51 5.3574e-17
C6_102 32 51 5.3574e-17
R6_11 31 32 52
C6_111 31 51 1.28578e-16
C6_112 32 51 1.28578e-16
R5_1 37 36 15
R5_2 37 38 26
C5_21 37 51 6.42888e-17
C5_22 38 51 6.42888e-17
R3_1 45 44 7.5
R3_2 47 46 15
R3_3 48 46 15
R3_4 47 48 13
C3_41 47 51 5.3574e-17
C3_42 48 51 5.3574e-17
R3_5 47 45 26
C3_51 47 51 6.42888e-17
C3_52 45 51 6.42888e-17
R2_1 54 52 15
R2_2 55 53 15
R2_3 51 55 26
C2_31 51 51 6.42888e-17
C2_32 55 51 6.42888e-17
R2_4 51 54 26
C2_41 51 51 6.42888e-17
C2_42 54 51 6.42888e-17
.ends noa2a22_x1
