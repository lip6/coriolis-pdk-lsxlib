* Spice description of no4_x4
* Spice driver version 1170525101
* Date ( dd/mm/yyyy hh:mm:ss ):  8/05/2026 at 14:22:51

* INTERF i0 i1 i2 i3 nq vdd vss

.subckt no4_x4 36 21 31 26 17 57 82
* NET 17 = nq
* NET 21 = i1
* NET 26 = i3
* NET 31 = i2
* NET 36 = i0
* NET 57 = vdd
* NET 82 = vss
Mtr_00014 51 76 11 57 sky130_fd_pr__pfet_01v8__model L=0.15U W=1.26U AS=0.3654P AD=0.3654P PS=3.1U PD=3.1U
Mtr_00013 41 38 72 57 sky130_fd_pr__pfet_01v8__model L=0.15U W=2.46U AS=0.7134P AD=0.7134P PS=5.5U PD=5.5U
Mtr_00012 47 33 44 57 sky130_fd_pr__pfet_01v8__model L=0.15U W=2.46U AS=0.7134P AD=0.7134P PS=5.5U PD=5.5U
Mtr_00011 18 8 51 57 sky130_fd_pr__pfet_01v8__model L=0.15U W=2.46U AS=0.7134P AD=0.7134P PS=5.5U PD=5.5U
Mtr_00010 50 7 18 57 sky130_fd_pr__pfet_01v8__model L=0.15U W=2.46U AS=0.7134P AD=0.7134P PS=5.5U PD=5.5U
Mtr_00009 44 23 41 57 sky130_fd_pr__pfet_01v8__model L=0.15U W=2.46U AS=0.7134P AD=0.7134P PS=5.5U PD=5.5U
Mtr_00008 50 28 47 57 sky130_fd_pr__pfet_01v8__model L=0.15U W=2.46U AS=0.7134P AD=0.7134P PS=5.5U PD=5.5U
Mtr_00007 3 67 89 82 sky130_fd_pr__nfet_01v8__model L=0.15U W=0.66U AS=0.1914P AD=0.1914P PS=1.9U PD=1.9U
Mtr_00006 83 37 60 82 sky130_fd_pr__nfet_01v8__model L=0.15U W=0.66U AS=0.1914P AD=0.1914P PS=1.9U PD=1.9U
Mtr_00005 60 22 85 82 sky130_fd_pr__nfet_01v8__model L=0.15U W=0.66U AS=0.1914P AD=0.1914P PS=1.9U PD=1.9U
Mtr_00004 89 2 16 82 sky130_fd_pr__nfet_01v8__model L=0.15U W=1.26U AS=0.3654P AD=0.3654P PS=3.1U PD=3.1U
Mtr_00003 16 1 87 82 sky130_fd_pr__nfet_01v8__model L=0.15U W=1.26U AS=0.3654P AD=0.3654P PS=3.1U PD=3.1U
Mtr_00002 63 27 87 82 sky130_fd_pr__nfet_01v8__model L=0.15U W=0.66U AS=0.1914P AD=0.1914P PS=1.9U PD=1.9U
Mtr_00001 85 32 63 82 sky130_fd_pr__nfet_01v8__model L=0.15U W=0.66U AS=0.1914P AD=0.1914P PS=1.9U PD=1.9U
R12_1 4 3 15
R12_2 13 11 15
R12_3 12 11 15
R12_4 10 9 15
R12_5 6 5 15
R12_6 2 6 288
C12_61 2 82 5.15424e-17
C12_62 6 82 5.15424e-17
R12_7 1 2 192
C12_71 1 82 3.86568e-17
C12_72 2 82 3.86568e-17
R12_8 8 10 288
C12_81 8 82 5.15424e-17
C12_82 10 82 5.15424e-17
R12_9 7 8 192
C12_91 7 82 3.86568e-17
C12_92 8 82 3.86568e-17
R12_10 12 13 26
C12_101 12 82 7.50036e-17
C12_102 13 82 7.50036e-17
R12_11 9 12 52
C12_111 9 82 1.39292e-16
C12_112 12 82 1.39292e-16
R12_12 5 9 26
C12_121 5 82 8.57184e-17
C12_122 9 82 8.57184e-17
R12_13 4 5 39
C12_131 4 82 1.07148e-16
C12_132 5 82 1.07148e-16
R11_1 17 16 7.5
R11_2 17 18 3.75
R10_1 23 21 15
R10_2 22 23 1008
C10_21 22 82 1.75566e-16
C10_22 23 82 1.75566e-16
R9_1 28 26 15
R9_2 27 28 1008
C9_21 27 82 1.75566e-16
C9_22 28 82 1.75566e-16
R8_1 33 31 15
R8_2 32 33 1008
C8_21 32 82 1.75566e-16
C8_22 33 82 1.75566e-16
R7_1 38 36 15
R7_2 37 38 1008
C7_21 37 82 1.75566e-16
C7_22 38 82 1.75566e-16
R3_1 50 55 15
R3_2 54 51 15
R3_3 53 51 15
R3_4 56 51 15
R3_5 52 51 15
R3_6 56 57 26
C3_61 56 82 6.42888e-17
C3_62 57 82 6.42888e-17
R3_7 54 56 26
C3_71 54 82 6.42888e-17
C3_72 56 82 6.42888e-17
R3_8 53 54 26
C3_81 53 82 6.42888e-17
C3_82 54 82 6.42888e-17
R3_9 52 53 13
C3_91 52 82 5.3574e-17
C3_92 53 82 5.3574e-17
R3_10 55 57 26
C3_101 55 82 6.42888e-17
C3_102 57 82 6.42888e-17
R2_1 61 60 15
R2_2 70 69 15
R2_3 64 63 15
R2_4 78 72 15
R2_5 73 72 15
R2_6 67 68 192
C2_61 67 82 3.86568e-17
C2_62 68 82 3.86568e-17
R2_7 76 77 192
C2_71 76 82 3.86568e-17
C2_72 77 82 3.86568e-17
R2_8 73 78 13
C2_81 73 82 5.3574e-17
C2_82 78 82 5.3574e-17
R2_9 71 77 528
C2_91 71 82 9.01992e-17
C2_92 77 82 9.01992e-17
R2_10 68 71 336
C2_101 68 82 5.79852e-17
C2_102 71 82 5.79852e-17
R2_11 78 79 78
C2_111 78 82 2.03581e-16
C2_112 79 82 2.03581e-16
R2_12 70 71 768
C2_121 70 82 1.28856e-16
C2_122 71 82 1.28856e-16
R2_13 74 79 13
C2_131 74 82 5.3574e-17
C2_132 79 82 5.3574e-17
R2_14 74 75 26
C2_141 74 82 6.42888e-17
C2_142 75 82 6.42888e-17
R2_15 64 65 13
C2_151 64 82 5.3574e-17
C2_152 65 82 5.3574e-17
R2_16 69 75 78
C2_161 69 82 2.03581e-16
C2_162 75 82 2.03581e-16
R2_17 66 69 39
C2_171 66 82 9.64332e-17
C2_172 69 82 9.64332e-17
R2_18 65 66 26
C2_181 65 82 7.50036e-17
C2_182 66 82 7.50036e-17
R2_19 62 65 52
C2_191 62 82 1.28578e-16
C2_192 65 82 1.28578e-16
R2_20 61 62 13
C2_201 61 82 5.3574e-17
C2_202 62 82 5.3574e-17
R1_1 84 83 15
R1_2 90 89 15
R1_3 91 89 15
R1_4 88 87 15
R1_5 86 85 15
R1_6 82 86 26
C1_61 82 82 6.42888e-17
C1_62 86 82 6.42888e-17
R1_7 82 88 26
C1_71 82 82 6.42888e-17
C1_72 88 82 6.42888e-17
R1_8 90 91 26
C1_81 90 82 7.50036e-17
C1_82 91 82 7.50036e-17
R1_9 82 90 26
C1_91 82 82 6.42888e-17
C1_92 90 82 6.42888e-17
R1_10 82 84 26
C1_101 82 82 6.42888e-17
C1_102 84 82 6.42888e-17
.ends no4_x4
