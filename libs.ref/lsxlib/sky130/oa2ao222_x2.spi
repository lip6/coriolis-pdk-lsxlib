* Spice description of oa2ao222_x2
* Spice driver version 134163373
* Date ( dd/mm/yyyy hh:mm:ss ):  8/05/2026 at 14:22:51

* INTERF i0 i1 i2 i3 i4 q vdd vss

.subckt oa2ao222_x2 50 32 46 2 39 28 24 85
* NET 2 = i3
* NET 24 = vdd
* NET 28 = q
* NET 32 = i1
* NET 39 = i4
* NET 46 = i2
* NET 50 = i0
* NET 85 = vss
Mtr_00012 29 78 17 24 sky130_fd_pr__pfet_01v8__model L=0.15U W=2.46U AS=0.7134P AD=0.7134P PS=5.5U PD=5.5U
Mtr_00011 56 45 79 24 sky130_fd_pr__pfet_01v8__model L=0.15U W=2.46U AS=0.7134P AD=0.7134P PS=5.5U PD=5.5U
Mtr_00010 7 3 56 24 sky130_fd_pr__pfet_01v8__model L=0.15U W=2.46U AS=0.7134P AD=0.7134P PS=5.5U PD=5.5U
Mtr_00009 20 53 8 24 sky130_fd_pr__pfet_01v8__model L=0.15U W=1.26U AS=0.3654P AD=0.3654P PS=3.1U PD=3.1U
Mtr_00008 20 35 9 24 sky130_fd_pr__pfet_01v8__model L=0.15U W=1.26U AS=0.3654P AD=0.3654P PS=3.1U PD=3.1U
Mtr_00007 79 41 9 24 sky130_fd_pr__pfet_01v8__model L=0.15U W=1.26U AS=0.3654P AD=0.3654P PS=3.1U PD=3.1U
Mtr_00006 90 72 27 85 sky130_fd_pr__nfet_01v8__model L=0.15U W=1.26U AS=0.3654P AD=0.3654P PS=3.1U PD=3.1U
Mtr_00005 61 1 88 85 sky130_fd_pr__nfet_01v8__model L=0.15U W=0.66U AS=0.1914P AD=0.1914P PS=1.9U PD=1.9U
Mtr_00004 67 51 86 85 sky130_fd_pr__nfet_01v8__model L=0.15U W=0.66U AS=0.1914P AD=0.1914P PS=1.9U PD=1.9U
Mtr_00003 88 44 59 85 sky130_fd_pr__nfet_01v8__model L=0.15U W=0.66U AS=0.1914P AD=0.1914P PS=1.9U PD=1.9U
Mtr_00002 59 38 70 85 sky130_fd_pr__nfet_01v8__model L=0.15U W=0.66U AS=0.1914P AD=0.1914P PS=1.9U PD=1.9U
Mtr_00001 70 33 67 85 sky130_fd_pr__nfet_01v8__model L=0.15U W=0.66U AS=0.1914P AD=0.1914P PS=1.9U PD=1.9U
R13_1 4 2 15
R13_2 4 3 480
C13_21 4 85 8.69778e-17
C13_22 3 85 8.69778e-17
R13_3 1 4 576
C13_31 1 85 9.6642e-17
C13_32 4 85 9.6642e-17
R12_1 14 7 15
R12_2 13 9 15
R12_3 11 9 15
R12_4 10 8 15
R12_5 12 8 15
R12_6 10 12 13
C12_61 10 85 5.3574e-17
C12_62 12 85 5.3574e-17
R12_7 10 11 52
C12_71 10 85 1.28578e-16
C12_72 11 85 1.28578e-16
R12_8 11 13 13
C12_81 11 85 5.3574e-17
C12_82 13 85 5.3574e-17
R12_9 13 14 78
C12_91 13 85 1.82152e-16
C12_92 14 85 1.82152e-16
R11_1 21 17 15
R11_2 23 17 15
R11_3 19 17 15
R11_4 17 18 15
R11_5 22 20 15
R11_6 22 24 26
C11_61 22 85 6.42888e-17
C11_62 24 85 6.42888e-17
R11_7 23 24 26
C11_71 23 85 6.42888e-17
C11_72 24 85 6.42888e-17
R11_8 21 23 26
C11_81 21 85 6.42888e-17
C11_82 23 85 6.42888e-17
R11_9 19 21 26
C11_91 19 85 6.42888e-17
C11_92 21 85 6.42888e-17
R11_10 18 19 13
C11_101 18 85 5.3574e-17
C11_102 19 85 5.3574e-17
R10_1 28 27 7.5
R10_2 28 29 3.75
R9_1 34 32 15
R9_2 34 35 672
C9_21 34 85 1.16776e-16
C9_22 35 85 1.16776e-16
R9_3 33 34 576
C9_31 33 85 9.6642e-17
C9_32 34 85 9.6642e-17
R8_1 40 39 15
R8_2 40 41 672
C8_21 40 85 1.16776e-16
C8_22 41 85 1.16776e-16
R8_3 38 40 576
C8_31 38 85 9.6642e-17
C8_32 40 85 9.6642e-17
R7_1 47 46 15
R7_2 47 45 480
C7_21 47 85 8.69778e-17
C7_22 45 85 8.69778e-17
R7_3 44 47 528
C7_31 44 85 9.4226e-17
C7_32 47 85 9.4226e-17
R6_1 52 50 15
R6_2 52 53 672
C6_21 52 85 1.19192e-16
C6_22 53 85 1.19192e-16
R6_3 51 52 576
C6_31 51 85 9.6642e-17
C6_32 52 85 9.6642e-17
R4_1 60 59 15
R4_2 62 61 15
R4_3 62 64 13
C4_31 62 85 5.3574e-17
C4_32 64 85 5.3574e-17
R4_4 63 64 52
C4_41 63 85 1.28578e-16
C4_42 64 85 1.28578e-16
R4_5 60 63 13
C4_51 60 85 5.3574e-17
C4_52 63 85 5.3574e-17
R2_1 71 70 15
R2_2 76 75 15
R2_3 80 79 15
R2_4 82 79 15
R2_5 81 79 15
R2_6 77 78 672
C2_61 77 85 1.19192e-16
C2_62 78 85 1.19192e-16
R2_7 72 77 288
C2_71 72 85 4.8321e-17
C2_72 77 85 4.8321e-17
R2_8 76 77 288
C2_81 76 85 5.15424e-17
C2_82 77 85 5.15424e-17
R2_9 80 82 26
C2_91 80 85 6.42888e-17
C2_92 82 85 6.42888e-17
R2_10 81 80 26
C2_101 81 85 6.42888e-17
C2_102 80 85 6.42888e-17
R2_11 74 81 52
C2_111 74 85 1.17863e-16
C2_112 81 85 1.17863e-16
R2_12 74 75 52
C2_121 74 85 1.39292e-16
C2_122 75 85 1.39292e-16
R2_13 73 74 13
C2_131 73 85 5.3574e-17
C2_132 74 85 5.3574e-17
R2_14 71 73 39
C2_141 71 85 1.07148e-16
C2_142 73 85 1.07148e-16
R1_1 88 89 15
R1_2 92 90 15
R1_3 91 90 15
R1_4 87 86 15
R1_5 85 87 26
C1_51 85 85 6.42888e-17
C1_52 87 85 6.42888e-17
R1_6 91 92 26
C1_61 91 85 7.50036e-17
C1_62 92 85 7.50036e-17
R1_7 85 91 26
C1_71 85 85 6.42888e-17
C1_72 91 85 6.42888e-17
R1_8 85 89 26
C1_81 85 85 6.42888e-17
C1_82 89 85 6.42888e-17
.ends oa2ao222_x2
