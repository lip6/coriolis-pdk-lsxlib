* Spice description of noa2ao222_x1
* Spice driver version 202423213
* Date ( dd/mm/yyyy hh:mm:ss ):  8/05/2026 at 14:22:51

* INTERF i0 i1 i2 i3 i4 nq nq vdd vss

.subckt noa2ao222_x1 28 34 22 6 41 50 51 3 55
* NET 3 = vdd
* NET 6 = i3
* NET 22 = i2
* NET 28 = i0
* NET 34 = i1
* NET 41 = i4
* NET 50 = nq
* NET 51 = nq
* NET 55 = vss
Mtr_00010 1 31 13 3 sky130_fd_pr__pfet_01v8__model L=0.15U W=1.5U AS=0.435P AD=0.435P PS=3.58U PD=3.58U
Mtr_00009 1 37 14 3 sky130_fd_pr__pfet_01v8__model L=0.15U W=1.5U AS=0.435P AD=0.435P PS=3.58U PD=3.58U
Mtr_00008 52 43 14 3 sky130_fd_pr__pfet_01v8__model L=0.15U W=1.5U AS=0.435P AD=0.435P PS=3.58U PD=3.58U
Mtr_00007 12 8 46 3 sky130_fd_pr__pfet_01v8__model L=0.15U W=2.46U AS=0.7134P AD=0.7134P PS=5.5U PD=5.5U
Mtr_00006 46 24 52 3 sky130_fd_pr__pfet_01v8__model L=0.15U W=2.46U AS=0.7134P AD=0.7134P PS=5.5U PD=5.5U
Mtr_00005 58 23 65 55 sky130_fd_pr__nfet_01v8__model L=0.15U W=0.78U AS=0.2262P AD=0.2262P PS=2.14U PD=2.14U
Mtr_00004 65 40 49 55 sky130_fd_pr__nfet_01v8__model L=0.15U W=0.78U AS=0.2262P AD=0.2262P PS=2.14U PD=2.14U
Mtr_00003 49 35 62 55 sky130_fd_pr__nfet_01v8__model L=0.15U W=0.78U AS=0.2262P AD=0.2262P PS=2.14U PD=2.14U
Mtr_00002 67 7 58 55 sky130_fd_pr__nfet_01v8__model L=0.15U W=0.78U AS=0.2262P AD=0.2262P PS=2.14U PD=2.14U
Mtr_00001 62 29 56 55 sky130_fd_pr__nfet_01v8__model L=0.15U W=0.78U AS=0.2262P AD=0.2262P PS=2.14U PD=2.14U
R12_1 2 1 15
R12_2 2 3 26
C12_21 2 55 6.42888e-17
C12_22 3 55 6.42888e-17
R11_1 9 6 15
R11_2 9 8 528
C11_21 9 55 9.34206e-17
C11_22 8 55 9.34206e-17
R11_3 7 9 480
C11_31 7 55 8.69778e-17
C11_32 9 55 8.69778e-17
R10_1 19 12 15
R10_2 18 14 15
R10_3 16 14 15
R10_4 15 13 15
R10_5 17 13 15
R10_6 15 17 13
C10_61 15 55 5.3574e-17
C10_62 17 55 5.3574e-17
R10_7 15 16 52
C10_71 15 55 1.28578e-16
C10_72 16 55 1.28578e-16
R10_8 16 18 13
C10_81 16 55 5.3574e-17
C10_82 18 55 5.3574e-17
R10_9 18 19 78
C10_91 18 55 1.82152e-16
C10_92 19 55 1.82152e-16
R9_1 25 22 15
R9_2 25 24 528
C9_21 25 55 9.34206e-17
C9_22 24 55 9.34206e-17
R9_3 23 25 480
C9_31 23 55 8.45618e-17
C9_32 25 55 8.45618e-17
R8_1 30 28 15
R8_2 30 31 672
C8_21 30 55 1.19192e-16
C8_22 31 55 1.19192e-16
R8_3 29 30 480
C8_31 29 55 8.69778e-17
C8_32 30 55 8.69778e-17
R7_1 36 34 15
R7_2 36 37 672
C7_21 36 55 1.16776e-16
C7_22 37 55 1.16776e-16
R7_3 35 36 480
C7_31 35 55 8.69778e-17
C7_32 36 55 8.69778e-17
R6_1 42 41 15
R6_2 42 43 672
C6_21 42 55 1.16776e-16
C6_22 43 55 1.16776e-16
R6_3 40 42 480
C6_31 40 55 8.69778e-17
C6_32 42 55 8.69778e-17
R4_1 50 49 15
R4_2 51 52 5
R4_3 50 51 26
C4_31 50 55 6.42888e-17
C4_32 51 55 6.42888e-17
R3_1 57 56 15
R3_2 59 58 15
R3_3 55 59 26
C3_31 55 55 6.42888e-17
C3_32 59 55 6.42888e-17
R3_4 55 57 26
C3_41 55 55 6.42888e-17
C3_42 57 55 6.42888e-17
R1_1 66 65 15
R1_2 68 67 15
R1_3 68 70 13
C1_31 68 55 5.3574e-17
C1_32 70 55 5.3574e-17
R1_4 69 70 52
C1_41 69 55 1.28578e-16
C1_42 70 55 1.28578e-16
R1_5 66 69 13
C1_51 66 55 5.3574e-17
C1_52 69 55 5.3574e-17
.ends noa2ao222_x1
