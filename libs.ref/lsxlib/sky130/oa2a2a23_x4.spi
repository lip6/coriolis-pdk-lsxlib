* Spice description of oa2a2a23_x4
* Spice driver version 2113330093
* Date ( dd/mm/yyyy hh:mm:ss ):  8/05/2026 at 14:22:51

* INTERF i0 i1 i2 i3 i4 i5 q vdd vss

.subckt oa2a2a23_x4 71 65 54 60 18 24 46 42 99
* NET 18 = i4
* NET 24 = i5
* NET 42 = vdd
* NET 46 = q
* NET 54 = i2
* NET 60 = i3
* NET 65 = i1
* NET 71 = i0
* NET 99 = vss
Mtr_00016 2 68 93 42 sky130_fd_pr__pfet_01v8__model L=0.15U W=1.5U AS=0.435P AD=0.435P PS=3.58U PD=3.58U
Mtr_00015 3 55 11 42 sky130_fd_pr__pfet_01v8__model L=0.15U W=1.5U AS=0.435P AD=0.435P PS=3.58U PD=3.58U
Mtr_00014 93 74 1 42 sky130_fd_pr__pfet_01v8__model L=0.15U W=1.5U AS=0.435P AD=0.435P PS=3.58U PD=3.58U
Mtr_00013 30 21 12 42 sky130_fd_pr__pfet_01v8__model L=0.15U W=1.5U AS=0.435P AD=0.435P PS=3.58U PD=3.58U
Mtr_00012 11 61 2 42 sky130_fd_pr__pfet_01v8__model L=0.15U W=1.5U AS=0.435P AD=0.435P PS=3.58U PD=3.58U
Mtr_00011 12 27 36 42 sky130_fd_pr__pfet_01v8__model L=0.15U W=1.5U AS=0.435P AD=0.435P PS=3.58U PD=3.58U
Mtr_00010 47 91 32 42 sky130_fd_pr__pfet_01v8__model L=0.15U W=2.46U AS=0.7134P AD=0.7134P PS=5.5U PD=5.5U
Mtr_00009 30 92 47 42 sky130_fd_pr__pfet_01v8__model L=0.15U W=2.46U AS=0.7134P AD=0.7134P PS=5.5U PD=5.5U
Mtr_00008 83 26 50 99 sky130_fd_pr__nfet_01v8__model L=0.15U W=0.78U AS=0.2262P AD=0.2262P PS=2.14U PD=2.14U
Mtr_00007 100 72 77 99 sky130_fd_pr__nfet_01v8__model L=0.15U W=0.78U AS=0.2262P AD=0.2262P PS=2.14U PD=2.14U
Mtr_00006 77 66 80 99 sky130_fd_pr__nfet_01v8__model L=0.15U W=0.78U AS=0.2262P AD=0.2262P PS=2.14U PD=2.14U
Mtr_00005 80 59 111 99 sky130_fd_pr__nfet_01v8__model L=0.15U W=0.78U AS=0.2262P AD=0.2262P PS=2.14U PD=2.14U
Mtr_00004 111 53 102 99 sky130_fd_pr__nfet_01v8__model L=0.15U W=0.78U AS=0.2262P AD=0.2262P PS=2.14U PD=2.14U
Mtr_00003 50 19 104 99 sky130_fd_pr__nfet_01v8__model L=0.15U W=0.78U AS=0.2262P AD=0.2262P PS=2.14U PD=2.14U
Mtr_00002 45 88 104 99 sky130_fd_pr__nfet_01v8__model L=0.15U W=1.26U AS=0.3654P AD=0.3654P PS=3.1U PD=3.1U
Mtr_00001 106 87 45 99 sky130_fd_pr__nfet_01v8__model L=0.15U W=1.26U AS=0.3654P AD=0.3654P PS=3.1U PD=3.1U
R15_1 7 2 15
R15_2 5 2 15
R15_3 8 3 15
R15_4 6 1 15
R15_5 4 1 15
R15_6 4 6 13
C15_61 4 99 5.3574e-17
C15_62 6 99 5.3574e-17
R15_7 7 8 52
C15_71 7 99 1.28578e-16
C15_72 8 99 1.28578e-16
R15_8 6 7 52
C15_81 6 99 1.28578e-16
C15_82 7 99 1.28578e-16
R15_9 5 7 13
C15_91 5 99 5.3574e-17
C15_92 7 99 5.3574e-17
R14_1 13 11 15
R14_2 14 12 15
R14_3 15 12 15
R14_4 14 15 13
C14_41 14 99 5.3574e-17
C14_42 15 99 5.3574e-17
R14_5 13 14 78
C14_51 13 99 1.92866e-16
C14_52 14 99 1.92866e-16
R13_1 20 18 15
R13_2 20 21 672
C13_21 20 99 1.19192e-16
C13_22 21 99 1.19192e-16
R13_3 19 20 480
C13_31 19 99 8.69778e-17
C13_32 20 99 8.69778e-17
R12_1 25 24 15
R12_2 25 27 672
C12_21 25 99 1.19192e-16
C12_22 27 99 1.19192e-16
R12_3 26 25 480
C12_31 26 99 8.69778e-17
C12_32 25 99 8.69778e-17
R11_1 38 32 15
R11_2 41 32 15
R11_3 35 32 15
R11_4 32 33 15
R11_5 34 30 15
R11_6 37 30 15
R11_7 40 30 15
R11_8 31 30 15
R11_9 39 36 15
R11_10 39 42 26
C11_101 39 99 6.42888e-17
C11_102 42 99 6.42888e-17
R11_11 40 42 26
C11_111 40 99 6.42888e-17
C11_112 42 99 6.42888e-17
R11_12 37 40 13
C11_121 37 99 5.3574e-17
C11_122 40 99 5.3574e-17
R11_13 34 37 26
C11_131 34 99 6.42888e-17
C11_132 37 99 6.42888e-17
R11_14 31 34 26
C11_141 31 99 6.42888e-17
C11_142 34 99 6.42888e-17
R11_15 41 42 26
C11_151 41 99 6.42888e-17
C11_152 42 99 6.42888e-17
R11_16 38 41 13
C11_161 38 99 5.3574e-17
C11_162 41 99 5.3574e-17
R11_17 35 38 26
C11_171 35 99 6.42888e-17
C11_172 38 99 6.42888e-17
R11_18 33 35 26
C11_181 33 99 6.42888e-17
C11_182 35 99 6.42888e-17
R10_1 46 45 7.5
R10_2 46 47 3.75
R8_1 56 54 15
R8_2 56 55 672
C8_21 56 99 1.19192e-16
C8_22 55 99 1.19192e-16
R8_3 53 56 480
C8_31 53 99 8.69778e-17
C8_32 56 99 8.69778e-17
R7_1 62 60 15
R7_2 62 61 672
C7_21 62 99 1.19192e-16
C7_22 61 99 1.19192e-16
R7_3 59 62 480
C7_31 59 99 8.69778e-17
C7_32 62 99 8.69778e-17
R6_1 67 65 15
R6_2 67 68 672
C6_21 67 99 1.19192e-16
C6_22 68 99 1.19192e-16
R6_3 66 67 480
C6_31 66 99 8.69778e-17
C6_32 67 99 8.69778e-17
R5_1 73 71 15
R5_2 73 74 672
C5_21 73 99 1.19192e-16
C5_22 74 99 1.19192e-16
R5_3 72 73 480
C5_31 72 99 8.69778e-17
C5_32 73 99 8.69778e-17
R3_1 81 80 15
R3_2 96 93 15
R3_3 84 83 15
R3_4 90 89 15
R3_5 90 92 528
C3_51 90 99 9.34206e-17
C3_52 92 99 9.34206e-17
R3_6 88 90 432
C3_61 88 99 7.40922e-17
C3_62 90 99 7.40922e-17
R3_7 90 91 528
C3_71 90 99 9.34206e-17
C3_72 91 99 9.34206e-17
R3_8 87 90 432
C3_81 87 99 7.40922e-17
C3_82 90 99 7.40922e-17
R3_9 86 89 39
C3_91 86 99 1.07148e-16
C3_92 89 99 1.07148e-16
R3_10 84 85 13
C3_101 84 99 5.3574e-17
C3_102 85 99 5.3574e-17
R3_11 95 96 13
C3_111 95 99 5.3574e-17
C3_112 96 99 5.3574e-17
R3_12 85 86 52
C3_121 85 99 1.39292e-16
C3_122 86 99 1.39292e-16
R3_13 82 85 78
C3_131 82 99 1.92866e-16
C3_132 85 99 1.92866e-16
R3_14 95 94 26
C3_141 95 99 6.42888e-17
C3_142 94 99 6.42888e-17
R3_15 82 94 104
C3_151 82 99 2.4644e-16
C3_152 94 99 2.4644e-16
R3_16 81 82 13
C3_161 81 99 5.3574e-17
C3_162 82 99 5.3574e-17
R2_1 103 102 15
R2_2 105 104 15
R2_3 107 106 15
R2_4 108 106 15
R2_5 101 100 15
R2_6 99 101 26
C2_61 99 99 6.42888e-17
C2_62 101 99 6.42888e-17
R2_7 107 108 26
C2_71 107 99 7.50036e-17
C2_72 108 99 7.50036e-17
R2_8 99 107 26
C2_81 99 99 6.42888e-17
C2_82 107 99 6.42888e-17
R2_9 99 105 26
C2_91 99 99 6.42888e-17
C2_92 105 99 6.42888e-17
R2_10 99 103 26
C2_101 99 99 6.42888e-17
C2_102 103 99 6.42888e-17
.ends oa2a2a23_x4
