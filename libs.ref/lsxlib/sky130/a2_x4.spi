* Spice description of a2_x4
* Spice driver version 1949920173
* Date ( dd/mm/yyyy hh:mm:ss ):  8/05/2026 at 14:22:51

* INTERF i0 i1 q vdd vss

.subckt a2_x4 8 1 29 22 33
* NET 1 = i1
* NET 8 = i0
* NET 22 = vdd
* NET 29 = q
* NET 33 = vss
Mtr_00008 13 50 30 22 sky130_fd_pr__pfet_01v8__model L=0.15U W=2.46U AS=0.7134P AD=0.7134P PS=5.5U PD=5.5U
Mtr_00007 30 51 15 22 sky130_fd_pr__pfet_01v8__model L=0.15U W=2.46U AS=0.7134P AD=0.7134P PS=5.5U PD=5.5U
Mtr_00006 18 4 52 22 sky130_fd_pr__pfet_01v8__model L=0.15U W=1.26U AS=0.3654P AD=0.3654P PS=3.1U PD=3.1U
Mtr_00005 52 10 15 22 sky130_fd_pr__pfet_01v8__model L=0.15U W=1.26U AS=0.3654P AD=0.3654P PS=3.1U PD=3.1U
Mtr_00004 35 43 28 33 sky130_fd_pr__nfet_01v8__model L=0.15U W=1.26U AS=0.3654P AD=0.3654P PS=3.1U PD=3.1U
Mtr_00003 25 2 45 33 sky130_fd_pr__nfet_01v8__model L=0.15U W=1.26U AS=0.3654P AD=0.3654P PS=3.1U PD=3.1U
Mtr_00002 35 7 25 33 sky130_fd_pr__nfet_01v8__model L=0.15U W=1.26U AS=0.3654P AD=0.3654P PS=3.1U PD=3.1U
Mtr_00001 28 42 34 33 sky130_fd_pr__nfet_01v8__model L=0.15U W=1.26U AS=0.3654P AD=0.3654P PS=3.1U PD=3.1U
R7_1 3 1 15
R7_2 3 4 672
C7_21 3 33 1.12749e-16
C7_22 4 33 1.12749e-16
R7_3 2 3 480
C7_31 2 33 8.69778e-17
C7_32 3 33 8.69778e-17
R6_1 9 8 15
R6_2 9 10 672
C6_21 9 33 1.12749e-16
C6_22 10 33 1.12749e-16
R6_3 7 9 480
C6_31 7 33 8.69778e-17
C6_32 9 33 8.69778e-17
R5_1 17 13 15
R5_2 16 13 15
R5_3 19 13 15
R5_4 13 14 15
R5_5 21 18 15
R5_6 20 15 15
R5_7 20 22 26
C5_71 20 33 6.42888e-17
C5_72 22 33 6.42888e-17
R5_8 21 22 26
C5_81 21 33 6.42888e-17
C5_82 22 33 6.42888e-17
R5_9 19 22 26
C5_91 19 33 6.42888e-17
C5_92 22 33 6.42888e-17
R5_10 17 19 13
C5_101 17 33 5.3574e-17
C5_102 19 33 5.3574e-17
R5_11 16 17 26
C5_111 16 33 6.42888e-17
C5_112 17 33 6.42888e-17
R5_12 14 16 26
C5_121 14 33 6.42888e-17
C5_122 16 33 6.42888e-17
R3_1 29 28 7.5
R3_2 29 30 3.75
R2_1 39 35 15
R2_2 37 35 15
R2_3 38 34 15
R2_4 36 34 15
R2_5 36 38 26
C2_51 36 33 7.50036e-17
C2_52 38 33 7.50036e-17
R2_6 33 36 26
C2_61 33 33 6.42888e-17
C2_62 36 33 6.42888e-17
R2_7 37 39 26
C2_71 37 33 7.50036e-17
C2_72 39 33 7.50036e-17
R2_8 33 37 26
C2_81 33 33 6.42888e-17
C2_82 37 33 6.42888e-17
R1_1 46 45 15
R1_2 54 52 15
R1_3 53 52 15
R1_4 47 48 15
R1_5 47 50 672
C1_51 47 33 1.12749e-16
C1_52 50 33 1.12749e-16
R1_6 42 47 288
C1_61 42 33 5.47638e-17
C1_62 47 33 5.47638e-17
R1_7 47 51 672
C1_71 47 33 1.12749e-16
C1_72 51 33 1.12749e-16
R1_8 43 47 288
C1_81 43 33 5.47638e-17
C1_82 47 33 5.47638e-17
R1_9 48 49 26
C1_91 48 33 7.50036e-17
C1_92 49 33 7.50036e-17
R1_10 53 54 26
C1_101 53 33 7.50036e-17
C1_102 54 33 7.50036e-17
R1_11 49 53 78
C1_111 49 33 2.03581e-16
C1_112 53 33 2.03581e-16
R1_12 44 49 52
C1_121 44 33 1.28578e-16
C1_122 49 33 1.28578e-16
R1_13 44 46 26
C1_131 44 33 6.42888e-17
C1_132 46 33 6.42888e-17
.ends a2_x4
