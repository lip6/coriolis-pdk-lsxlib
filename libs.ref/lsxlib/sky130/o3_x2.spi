* Spice description of o3_x2
* Spice driver version -1866630227
* Date ( dd/mm/yyyy hh:mm:ss ):  8/05/2026 at 14:22:51

* INTERF i0 i1 i2 q vdd vss

.subckt o3_x2 15 1 7 31 21 35
* NET 1 = i1
* NET 7 = i2
* NET 15 = i0
* NET 21 = vdd
* NET 31 = q
* NET 35 = vss
Mtr_00008 19 13 24 21 sky130_fd_pr__pfet_01v8__model L=0.15U W=2.46U AS=0.7134P AD=0.7134P PS=5.5U PD=5.5U
Mtr_00007 24 3 27 21 sky130_fd_pr__pfet_01v8__model L=0.15U W=2.46U AS=0.7134P AD=0.7134P PS=5.5U PD=5.5U
Mtr_00006 52 9 27 21 sky130_fd_pr__pfet_01v8__model L=0.15U W=2.46U AS=0.7134P AD=0.7134P PS=5.5U PD=5.5U
Mtr_00005 32 51 19 21 sky130_fd_pr__pfet_01v8__model L=0.15U W=2.46U AS=0.7134P AD=0.7134P PS=5.5U PD=5.5U
Mtr_00004 36 8 42 35 sky130_fd_pr__nfet_01v8__model L=0.15U W=0.66U AS=0.1914P AD=0.1914P PS=1.9U PD=1.9U
Mtr_00003 36 2 45 35 sky130_fd_pr__nfet_01v8__model L=0.15U W=0.66U AS=0.1914P AD=0.1914P PS=1.9U PD=1.9U
Mtr_00002 45 14 37 35 sky130_fd_pr__nfet_01v8__model L=0.15U W=0.66U AS=0.1914P AD=0.1914P PS=1.9U PD=1.9U
Mtr_00001 30 48 37 35 sky130_fd_pr__nfet_01v8__model L=0.15U W=1.26U AS=0.3654P AD=0.3654P PS=3.1U PD=3.1U
R9_1 4 1 15
R9_2 4 3 480
C9_21 4 35 8.69778e-17
C9_22 3 35 8.69778e-17
R9_3 2 4 576
C9_31 2 35 9.6642e-17
C9_32 4 35 9.6642e-17
R8_1 10 7 15
R8_2 10 9 480
C8_21 10 35 8.69778e-17
C8_22 9 35 8.69778e-17
R8_3 8 10 576
C8_31 8 35 9.6642e-17
C8_32 10 35 9.6642e-17
R7_1 16 15 15
R7_2 16 13 480
C7_21 16 35 8.69778e-17
C7_22 13 35 8.69778e-17
R7_3 14 16 576
C7_31 14 35 9.6642e-17
C7_32 16 35 9.6642e-17
R6_1 20 19 15
R6_2 20 21 26
C6_21 20 35 6.42888e-17
C6_22 21 35 6.42888e-17
R3_1 30 31 7.5
R3_2 31 32 3.75
R2_1 38 36 15
R2_2 39 37 7.5
R2_3 35 39 26
C2_31 35 35 6.42888e-17
C2_32 39 35 6.42888e-17
R2_4 35 38 26
C2_41 35 35 6.42888e-17
C2_42 38 35 6.42888e-17
R1_1 46 45 15
R1_2 56 52 15
R1_3 55 52 15
R1_4 53 52 15
R1_5 54 52 15
R1_6 43 42 15
R1_7 48 50 15
R1_8 48 51 912
C1_81 48 35 1.59459e-16
C1_82 51 35 1.59459e-16
R1_9 49 50 26
C1_91 49 35 6.42888e-17
C1_92 50 35 6.42888e-17
R1_10 55 56 13
C1_101 55 35 5.3574e-17
C1_102 56 35 5.3574e-17
R1_11 53 55 26
C1_111 53 35 6.42888e-17
C1_112 55 35 6.42888e-17
R1_12 54 53 26
C1_121 54 35 6.42888e-17
C1_122 53 35 6.42888e-17
R1_13 44 54 65
C1_131 44 35 1.71437e-16
C1_132 54 35 1.71437e-16
R1_14 43 44 13
C1_141 43 35 5.3574e-17
C1_142 44 35 5.3574e-17
R1_15 47 49 26
C1_151 47 35 7.50036e-17
C1_152 49 35 7.50036e-17
R1_16 44 47 52
C1_161 44 35 1.28578e-16
C1_162 47 35 1.28578e-16
R1_17 46 47 13
C1_171 46 35 5.3574e-17
C1_172 47 35 5.3574e-17
.ends o3_x2
