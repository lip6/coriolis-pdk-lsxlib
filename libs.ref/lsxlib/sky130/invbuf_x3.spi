* Spice description of invbuf_x3
* Spice driver version -1728586835
* Date ( dd/mm/yyyy hh:mm:ss ):  8/05/2026 at 14:22:51

* INTERF c0 c1 i vdd vss

.subckt invbuf_x3 51 37 18 13 24
* NET 13 = vdd
* NET 18 = i
* NET 24 = vss
* NET 37 = c1
* NET 51 = c0
Mtr_00008 58 19 3 13 sky130_fd_pr__pfet_01v8__model L=0.15U W=1.74U AS=0.5046P AD=0.5046P PS=4.06U PD=4.06U
Mtr_00007 3 57 40 13 sky130_fd_pr__pfet_01v8__model L=0.15U W=1.74U AS=0.5046P AD=0.5046P PS=4.06U PD=4.06U
Mtr_00006 40 56 1 13 sky130_fd_pr__pfet_01v8__model L=0.15U W=1.74U AS=0.5046P AD=0.5046P PS=4.06U PD=4.06U
Mtr_00005 5 21 58 13 sky130_fd_pr__pfet_01v8__model L=0.15U W=1.74U AS=0.5046P AD=0.5046P PS=4.06U PD=4.06U
Mtr_00004 48 17 29 24 sky130_fd_pr__nfet_01v8__model L=0.15U W=0.9U AS=0.261P AD=0.261P PS=2.38U PD=2.38U
Mtr_00003 25 46 36 24 sky130_fd_pr__nfet_01v8__model L=0.15U W=0.9U AS=0.261P AD=0.261P PS=2.38U PD=2.38U
Mtr_00002 36 47 27 24 sky130_fd_pr__nfet_01v8__model L=0.15U W=0.9U AS=0.261P AD=0.261P PS=2.38U PD=2.38U
Mtr_00001 27 16 48 24 sky130_fd_pr__nfet_01v8__model L=0.15U W=0.9U AS=0.261P AD=0.261P PS=2.38U PD=2.38U
R5_1 4 3 15
R5_2 11 3 15
R5_3 8 3 15
R5_4 12 5 15
R5_5 9 5 15
R5_6 6 5 15
R5_7 7 1 15
R5_8 2 1 15
R5_9 10 1 15
R5_10 10 13 26
C5_101 10 24 6.42888e-17
C5_102 13 24 6.42888e-17
R5_11 7 10 13
C5_111 7 24 5.3574e-17
C5_112 10 24 5.3574e-17
R5_12 2 7 13
C5_121 2 24 5.3574e-17
C5_122 7 24 5.3574e-17
R5_13 12 13 26
C5_131 12 24 6.42888e-17
C5_132 13 24 6.42888e-17
R5_14 9 12 13
C5_141 9 24 5.3574e-17
C5_142 12 24 5.3574e-17
R5_15 6 9 13
C5_151 6 24 5.3574e-17
C5_152 9 24 5.3574e-17
R5_16 11 13 26
C5_161 11 24 6.42888e-17
C5_162 13 24 6.42888e-17
R5_17 8 11 13
C5_171 8 24 5.3574e-17
C5_172 11 24 5.3574e-17
R5_18 4 8 13
C5_181 4 24 5.3574e-17
C5_182 8 24 5.3574e-17
R4_1 20 18 15
R4_2 20 21 480
C4_21 20 24 8.69778e-17
C4_22 21 24 8.69778e-17
R4_3 17 20 624
C4_31 17 24 1.09528e-16
C4_32 20 24 1.09528e-16
R4_4 20 19 480
C4_41 20 24 8.69778e-17
C4_42 19 24 8.69778e-17
R4_5 16 20 624
C4_51 16 24 1.09528e-16
C4_52 20 24 1.09528e-16
R3_1 28 27 15
R3_2 32 27 15
R3_3 30 29 15
R3_4 33 29 15
R3_5 31 25 15
R3_6 26 25 15
R3_7 26 31 13
C3_71 26 24 4.28592e-17
C3_72 31 24 4.28592e-17
R3_8 24 26 26
C3_81 24 24 6.42888e-17
C3_82 26 24 6.42888e-17
R3_9 30 33 13
C3_91 30 24 4.28592e-17
C3_92 33 24 4.28592e-17
R3_10 24 30 26
C3_101 24 24 6.42888e-17
C3_102 30 24 6.42888e-17
R3_11 28 32 13
C3_111 28 24 4.28592e-17
C3_112 32 24 4.28592e-17
R3_12 24 28 26
C3_121 24 24 6.42888e-17
C3_122 28 24 6.42888e-17
R2_1 38 36 15
R2_2 39 36 15
R2_3 41 40 15
R2_4 42 40 15
R2_5 43 40 15
R2_6 43 42 13
C2_61 43 24 5.3574e-17
C2_62 42 24 5.3574e-17
R2_7 41 43 13
C2_71 41 24 5.3574e-17
C2_72 43 24 5.3574e-17
R2_8 37 41 78
C2_81 37 24 1.92866e-16
C2_82 41 24 1.92866e-16
R2_9 38 37 26
C2_91 38 24 6.42888e-17
C2_92 37 24 6.42888e-17
R2_10 39 38 13
C2_101 39 24 4.28592e-17
C2_102 38 24 4.28592e-17
R1_1 49 48 15
R1_2 50 48 15
R1_3 59 58 15
R1_4 61 58 15
R1_5 60 58 15
R1_6 53 54 15
R1_7 53 57 480
C1_71 53 24 8.69778e-17
C1_72 57 24 8.69778e-17
R1_8 47 53 624
C1_81 47 24 1.09528e-16
C1_82 53 24 1.09528e-16
R1_9 53 56 480
C1_91 53 24 8.69778e-17
C1_92 56 24 8.69778e-17
R1_10 46 53 624
C1_101 46 24 1.09528e-16
C1_102 53 24 1.09528e-16
R1_11 54 55 26
C1_111 54 24 7.50036e-17
C1_112 55 24 7.50036e-17
R1_12 51 52 13
C1_121 51 24 5.3574e-17
C1_122 52 24 5.3574e-17
R1_13 60 61 13
C1_131 60 24 5.3574e-17
C1_132 61 24 5.3574e-17
R1_14 59 60 13
C1_141 59 24 5.3574e-17
C1_142 60 24 5.3574e-17
R1_15 55 59 39
C1_151 55 24 9.64332e-17
C1_152 59 24 9.64332e-17
R1_16 52 55 39
C1_161 52 24 9.64332e-17
C1_162 55 24 9.64332e-17
R1_17 50 52 26
C1_171 50 24 6.42888e-17
C1_172 52 24 6.42888e-17
R1_18 49 50 13
C1_181 49 24 4.28592e-17
C1_182 50 24 4.28592e-17
.ends invbuf_x3
