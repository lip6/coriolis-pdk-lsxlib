* Spice description of on12_x4
* Spice driver version 1886411693
* Date ( dd/mm/yyyy hh:mm:ss ):  8/05/2026 at 14:22:51

* INTERF i0 i1 q vdd vss

.subckt on12_x4 1 22 60 42 64
* NET 1 = i0
* NET 22 = i1
* NET 42 = vdd
* NET 60 = q
* NET 64 = vss
Mtr_00010 8 14 34 42 sky130_fd_pr__pfet_01v8__model L=0.15U W=2.46U AS=0.7134P AD=0.7134P PS=5.5U PD=5.5U
Mtr_00009 51 27 8 42 sky130_fd_pr__pfet_01v8__model L=0.15U W=2.46U AS=0.7134P AD=0.7134P PS=5.5U PD=5.5U
Mtr_00008 34 5 17 42 sky130_fd_pr__pfet_01v8__model L=0.15U W=1.02U AS=0.2958P AD=0.2958P PS=2.62U PD=2.62U
Mtr_00007 30 49 61 42 sky130_fd_pr__pfet_01v8__model L=0.15U W=2.46U AS=0.7134P AD=0.7134P PS=5.5U PD=5.5U
Mtr_00006 61 50 32 42 sky130_fd_pr__pfet_01v8__model L=0.15U W=2.46U AS=0.7134P AD=0.7134P PS=5.5U PD=5.5U
Mtr_00005 46 23 69 64 sky130_fd_pr__nfet_01v8__model L=0.15U W=0.66U AS=0.1914P AD=0.1914P PS=1.9U PD=1.9U
Mtr_00004 71 11 46 64 sky130_fd_pr__nfet_01v8__model L=0.15U W=0.66U AS=0.1914P AD=0.1914P PS=1.9U PD=1.9U
Mtr_00003 12 3 71 64 sky130_fd_pr__nfet_01v8__model L=0.15U W=0.54U AS=0.1566P AD=0.1566P PS=1.66U PD=1.66U
Mtr_00002 67 45 59 64 sky130_fd_pr__nfet_01v8__model L=0.15U W=1.26U AS=0.3654P AD=0.3654P PS=3.1U PD=3.1U
Mtr_00001 59 45 65 64 sky130_fd_pr__nfet_01v8__model L=0.15U W=1.26U AS=0.3654P AD=0.3654P PS=3.1U PD=3.1U
R8_1 4 1 15
R8_2 2 1 15
R8_3 3 2 192
C8_31 3 64 3.54354e-17
C8_32 2 64 3.54354e-17
R8_4 4 5 720
C8_41 4 64 1.25635e-16
C8_42 5 64 1.25635e-16
R6_1 12 13 15
R6_2 18 17 15
R6_3 19 17 15
R6_4 15 16 15
R6_5 15 14 672
C6_51 15 64 1.19192e-16
C6_52 14 64 1.19192e-16
R6_6 11 15 384
C6_61 11 64 6.4428e-17
C6_62 15 64 6.4428e-17
R6_7 19 18 13
C6_71 19 64 5.3574e-17
C6_72 18 64 5.3574e-17
R6_8 16 19 104
C6_81 16 64 2.35726e-16
C6_82 19 64 2.35726e-16
R6_9 13 16 52
C6_91 13 64 1.17863e-16
C6_92 16 64 1.17863e-16
R5_1 25 26 15
R5_2 23 24 15
R5_3 22 24 13
C5_31 22 64 5.3574e-17
C5_32 24 64 5.3574e-17
R5_4 22 26 13
C5_41 22 64 5.3574e-17
C5_42 26 64 5.3574e-17
R5_5 25 27 480
C5_51 25 64 8.69778e-17
C5_52 27 64 8.69778e-17
R4_1 35 30 15
R4_2 39 30 15
R4_3 37 30 15
R4_4 30 31 15
R4_5 41 34 15
R4_6 36 32 15
R4_7 38 32 15
R4_8 40 32 15
R4_9 33 32 15
R4_10 40 42 26
C4_101 40 64 6.42888e-17
C4_102 42 64 6.42888e-17
R4_11 38 40 26
C4_111 38 64 6.42888e-17
C4_112 40 64 6.42888e-17
R4_12 36 38 13
C4_121 36 64 5.3574e-17
C4_122 38 64 5.3574e-17
R4_13 33 36 26
C4_131 33 64 6.42888e-17
C4_132 36 64 6.42888e-17
R4_14 41 42 26
C4_141 41 64 6.42888e-17
C4_142 42 64 6.42888e-17
R4_15 39 42 26
C4_151 39 64 6.42888e-17
C4_152 42 64 6.42888e-17
R4_16 37 39 26
C4_161 37 64 6.42888e-17
C4_162 39 64 6.42888e-17
R4_17 35 37 13
C4_171 35 64 5.3574e-17
C4_172 37 64 5.3574e-17
R4_18 31 35 26
C4_181 31 64 6.42888e-17
C4_182 35 64 6.42888e-17
R3_1 47 46 15
R3_2 45 48 15
R3_3 52 51 15
R3_4 54 51 15
R3_5 55 51 15
R3_6 56 51 15
R3_7 45 50 912
C3_71 45 64 1.59459e-16
C3_72 50 64 1.59459e-16
R3_8 45 49 912
C3_81 45 64 1.59459e-16
C3_82 49 64 1.59459e-16
R3_9 54 56 26
C3_91 54 64 6.42888e-17
C3_92 56 64 6.42888e-17
R3_10 55 54 13
C3_101 55 64 5.3574e-17
C3_102 54 64 5.3574e-17
R3_11 52 55 26
C3_111 52 64 6.42888e-17
C3_112 55 64 6.42888e-17
R3_12 52 53 13
C3_121 52 64 5.3574e-17
C3_122 53 64 5.3574e-17
R3_13 48 53 39
C3_131 48 64 1.07148e-16
C3_132 53 64 1.07148e-16
R3_14 47 48 52
C3_141 47 64 1.17863e-16
C3_142 48 64 1.17863e-16
R2_1 60 59 7.5
R2_2 60 61 3.75
R1_1 70 69 15
R1_2 72 71 15
R1_3 73 65 15
R1_4 66 65 15
R1_5 68 67 15
R1_6 74 67 15
R1_7 68 74 26
C1_71 68 64 7.50036e-17
C1_72 74 64 7.50036e-17
R1_8 64 68 26
C1_81 64 64 6.42888e-17
C1_82 68 64 6.42888e-17
R1_9 66 73 26
C1_91 66 64 7.50036e-17
C1_92 73 64 7.50036e-17
R1_10 64 66 26
C1_101 64 64 6.42888e-17
C1_102 66 64 6.42888e-17
R1_11 64 72 26
C1_111 64 64 6.42888e-17
C1_112 72 64 6.42888e-17
R1_12 64 70 26
C1_121 64 64 6.42888e-17
C1_122 70 64 6.42888e-17
.ends on12_x4
