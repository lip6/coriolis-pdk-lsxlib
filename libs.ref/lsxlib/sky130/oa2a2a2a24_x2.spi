* Spice description of oa2a2a2a24_x2
* Spice driver version -2047157331
* Date ( dd/mm/yyyy hh:mm:ss ):  8/05/2026 at 14:23:17

* INTERF i0 i1 i2 i3 i4 i5 i6 i7 q vdd vss

.subckt oa2a2a2a24_x2 51 63 59 46 24 18 6 12 2 76 98
* NET 2 = q
* NET 6 = i6
* NET 12 = i7
* NET 18 = i5
* NET 24 = i4
* NET 46 = i3
* NET 51 = i0
* NET 59 = i2
* NET 63 = i1
* NET 76 = vdd
* NET 98 = vss
Mtr_00018 86 66 69 76 sky130_fd_pr__pfet_01v8__model L=0.15U W=2.46U AS=0.7134P AD=0.7134P PS=5.5U PD=5.5U
Mtr_00017 87 58 79 76 sky130_fd_pr__pfet_01v8__model L=0.15U W=2.46U AS=0.7134P AD=0.7134P PS=5.5U PD=5.5U
Mtr_00016 32 15 122 76 sky130_fd_pr__pfet_01v8__model L=0.15U W=2.46U AS=0.7134P AD=0.7134P PS=5.5U PD=5.5U
Mtr_00015 69 54 85 76 sky130_fd_pr__pfet_01v8__model L=0.15U W=2.46U AS=0.7134P AD=0.7134P PS=5.5U PD=5.5U
Mtr_00014 122 9 31 76 sky130_fd_pr__pfet_01v8__model L=0.15U W=2.46U AS=0.7134P AD=0.7134P PS=5.5U PD=5.5U
Mtr_00013 80 27 30 76 sky130_fd_pr__pfet_01v8__model L=0.15U W=2.46U AS=0.7134P AD=0.7134P PS=5.5U PD=5.5U
Mtr_00012 79 47 86 76 sky130_fd_pr__pfet_01v8__model L=0.15U W=2.46U AS=0.7134P AD=0.7134P PS=5.5U PD=5.5U
Mtr_00011 31 21 80 76 sky130_fd_pr__pfet_01v8__model L=0.15U W=2.46U AS=0.7134P AD=0.7134P PS=5.5U PD=5.5U
Mtr_00010 3 123 70 76 sky130_fd_pr__pfet_01v8__model L=0.15U W=2.46U AS=0.7134P AD=0.7134P PS=5.5U PD=5.5U
Mtr_00009 42 19 115 98 sky130_fd_pr__nfet_01v8__model L=0.15U W=0.78U AS=0.2262P AD=0.2262P PS=2.14U PD=2.14U
Mtr_00008 112 45 95 98 sky130_fd_pr__nfet_01v8__model L=0.15U W=0.78U AS=0.2262P AD=0.2262P PS=2.14U PD=2.14U
Mtr_00007 103 25 42 98 sky130_fd_pr__nfet_01v8__model L=0.15U W=0.78U AS=0.2262P AD=0.2262P PS=2.14U PD=2.14U
Mtr_00006 95 57 101 98 sky130_fd_pr__nfet_01v8__model L=0.15U W=0.78U AS=0.2262P AD=0.2262P PS=2.14U PD=2.14U
Mtr_00005 115 7 39 98 sky130_fd_pr__nfet_01v8__model L=0.15U W=0.78U AS=0.2262P AD=0.2262P PS=2.14U PD=2.14U
Mtr_00004 39 13 105 98 sky130_fd_pr__nfet_01v8__model L=0.15U W=0.78U AS=0.2262P AD=0.2262P PS=2.14U PD=2.14U
Mtr_00003 99 52 128 98 sky130_fd_pr__nfet_01v8__model L=0.15U W=0.78U AS=0.2262P AD=0.2262P PS=2.14U PD=2.14U
Mtr_00002 128 64 112 98 sky130_fd_pr__nfet_01v8__model L=0.15U W=0.78U AS=0.2262P AD=0.2262P PS=2.14U PD=2.14U
Mtr_00001 107 118 1 98 sky130_fd_pr__nfet_01v8__model L=0.15U W=1.26U AS=0.3654P AD=0.3654P PS=3.1U PD=3.1U
R19_1 2 1 7.5
R19_2 2 3 3.75
R18_1 8 6 15
R18_2 8 9 528
C18_21 8 98 9.34206e-17
C18_22 9 98 9.34206e-17
R18_3 7 8 480
C18_31 7 98 8.69778e-17
C18_32 8 98 8.69778e-17
R17_1 14 12 15
R17_2 14 15 528
C17_21 14 98 9.34206e-17
C17_22 15 98 9.34206e-17
R17_3 13 14 480
C17_31 13 98 8.69778e-17
C17_32 14 98 8.69778e-17
R16_1 20 18 15
R16_2 20 21 528
C16_21 20 98 9.34206e-17
C16_22 21 98 9.34206e-17
R16_3 19 20 480
C16_31 19 98 8.69778e-17
C16_32 20 98 8.69778e-17
R15_1 26 24 15
R15_2 26 27 528
C15_21 26 98 9.34206e-17
C15_22 27 98 9.34206e-17
R15_3 25 26 480
C15_31 25 98 8.69778e-17
C15_32 26 98 8.69778e-17
R14_1 32 36 15
R14_2 35 31 15
R14_3 34 31 15
R14_4 33 30 15
R14_5 33 34 52
C14_51 33 98 1.28578e-16
C14_52 34 98 1.28578e-16
R14_6 34 35 13
C14_61 34 98 5.3574e-17
C14_62 35 98 5.3574e-17
R14_7 35 36 52
C14_71 35 98 1.28578e-16
C14_72 36 98 1.28578e-16
R11_1 48 46 15
R11_2 48 47 528
C11_21 48 98 9.34206e-17
C11_22 47 98 9.34206e-17
R11_3 45 48 480
C11_31 45 98 8.69778e-17
C11_32 48 98 8.69778e-17
R10_1 53 51 15
R10_2 53 54 528
C10_21 53 98 9.34206e-17
C10_22 54 98 9.34206e-17
R10_3 52 53 480
C10_31 52 98 8.69778e-17
C10_32 53 98 8.69778e-17
R9_1 60 59 15
R9_2 60 58 528
C9_21 60 98 9.34206e-17
C9_22 58 98 9.34206e-17
R9_3 57 60 480
C9_31 57 98 8.69778e-17
C9_32 60 98 8.69778e-17
R8_1 65 63 15
R8_2 65 66 528
C8_21 65 98 9.34206e-17
C8_22 66 98 9.34206e-17
R8_3 64 65 480
C8_31 64 98 8.69778e-17
C8_32 65 98 8.69778e-17
R7_1 74 69 15
R7_2 72 70 15
R7_3 73 70 15
R7_4 75 70 15
R7_5 71 70 15
R7_6 75 76 26
C7_61 75 98 6.42888e-17
C7_62 76 98 6.42888e-17
R7_7 73 75 13
C7_71 73 98 5.3574e-17
C7_72 75 98 5.3574e-17
R7_8 72 73 26
C7_81 72 98 6.42888e-17
C7_82 73 98 6.42888e-17
R7_9 71 72 26
C7_91 71 98 6.42888e-17
C7_92 72 98 6.42888e-17
R7_10 74 76 26
C7_101 74 98 6.42888e-17
C7_102 76 98 6.42888e-17
R6_1 81 79 15
R6_2 82 80 15
R6_3 81 82 78
C6_31 81 98 1.92866e-16
C6_32 82 98 1.92866e-16
R5_1 90 87 15
R5_2 89 86 15
R5_3 88 85 15
R5_4 91 85 15
R5_5 92 86 15
R5_6 89 92 13
C5_61 89 98 5.3574e-17
C5_62 92 98 5.3574e-17
R5_7 88 91 13
C5_71 88 98 5.3574e-17
C5_72 91 98 5.3574e-17
R5_8 89 90 52
C5_81 89 98 1.28578e-16
C5_82 90 98 1.28578e-16
R5_9 88 89 52
C5_91 88 98 1.28578e-16
C5_92 89 98 1.28578e-16
R3_1 100 99 15
R3_2 109 107 15
R3_3 108 107 15
R3_4 102 101 15
R3_5 104 103 15
R3_6 106 105 15
R3_7 98 106 26
C3_71 98 98 6.42888e-17
C3_72 106 98 6.42888e-17
R3_8 98 104 26
C3_81 98 98 6.42888e-17
C3_82 104 98 6.42888e-17
R3_9 98 102 26
C3_91 98 98 6.42888e-17
C3_92 102 98 6.42888e-17
R3_10 108 109 26
C3_101 108 98 7.50036e-17
C3_102 109 98 7.50036e-17
R3_11 98 108 26
C3_111 98 98 6.42888e-17
C3_112 108 98 6.42888e-17
R3_12 98 100 26
C3_121 98 98 6.42888e-17
C3_122 100 98 6.42888e-17
R2_1 113 112 15
R2_2 121 120 15
R2_3 116 115 15
R2_4 124 122 15
R2_5 121 123 528
C2_51 121 98 9.34206e-17
C2_52 123 98 9.34206e-17
R2_6 118 121 432
C2_61 118 98 7.40922e-17
C2_62 121 98 7.40922e-17
R2_7 124 125 26
C2_71 124 98 7.50036e-17
C2_72 125 98 7.50036e-17
R2_8 116 117 13
C2_81 116 98 5.3574e-17
C2_82 117 98 5.3574e-17
R2_9 120 125 78
C2_91 120 98 1.92866e-16
C2_92 125 98 1.92866e-16
R2_10 119 120 39
C2_101 119 98 1.07148e-16
C2_102 120 98 1.07148e-16
R2_11 117 119 52
C2_111 117 98 1.39292e-16
C2_112 119 98 1.39292e-16
R2_12 114 117 130
C2_121 114 98 3.21444e-16
C2_122 117 98 3.21444e-16
R2_13 113 114 13
C2_131 113 98 5.3574e-17
C2_132 114 98 5.3574e-17
.ends oa2a2a2a24_x2
