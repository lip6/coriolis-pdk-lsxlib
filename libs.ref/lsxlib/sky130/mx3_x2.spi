* Spice description of mx3_x2
* Spice driver version 1294465965
* Date ( dd/mm/yyyy hh:mm:ss ):  8/05/2026 at 14:23:17

* INTERF cmd0 cmd1 i0 i1 i2 q vdd vss

.subckt mx3_x2 17 69 29 57 64 50 88 122
* NET 17 = cmd0
* NET 29 = i0
* NET 50 = q
* NET 57 = i1
* NET 64 = i2
* NET 69 = cmd1
* NET 88 = vdd
* NET 122 = vss
Mtr_00020 51 111 83 88 sky130_fd_pr__pfet_01v8__model L=0.15U W=2.46U AS=0.7134P AD=0.7134P PS=5.5U PD=5.5U
Mtr_00019 83 23 43 88 sky130_fd_pr__pfet_01v8__model L=0.15U W=0.78U AS=0.2262P AD=0.2262P PS=2.14U PD=2.14U
Mtr_00018 135 72 82 88 sky130_fd_pr__pfet_01v8__model L=0.15U W=0.78U AS=0.2262P AD=0.2262P PS=2.14U PD=2.14U
Mtr_00017 117 31 1 88 sky130_fd_pr__pfet_01v8__model L=0.15U W=1.14U AS=0.3306P AD=0.3306P PS=2.86U PD=2.86U
Mtr_00016 13 66 7 88 sky130_fd_pr__pfet_01v8__model L=0.15U W=1.14U AS=0.3306P AD=0.3306P PS=2.86U PD=2.86U
Mtr_00015 114 78 13 88 sky130_fd_pr__pfet_01v8__model L=0.15U W=1.14U AS=0.3306P AD=0.3306P PS=2.86U PD=2.86U
Mtr_00014 4 138 114 88 sky130_fd_pr__pfet_01v8__model L=0.15U W=1.14U AS=0.3306P AD=0.3306P PS=2.86U PD=2.86U
Mtr_00013 1 24 84 88 sky130_fd_pr__pfet_01v8__model L=0.15U W=1.14U AS=0.3306P AD=0.3306P PS=2.86U PD=2.86U
Mtr_00012 84 45 8 88 sky130_fd_pr__pfet_01v8__model L=0.15U W=1.14U AS=0.3306P AD=0.3306P PS=2.86U PD=2.86U
Mtr_00011 8 60 4 88 sky130_fd_pr__pfet_01v8__model L=0.15U W=1.14U AS=0.3306P AD=0.3306P PS=2.86U PD=2.86U
Mtr_00010 49 109 127 122 sky130_fd_pr__nfet_01v8__model L=0.15U W=1.26U AS=0.3654P AD=0.3654P PS=3.1U PD=3.1U
Mtr_00009 106 28 54 122 sky130_fd_pr__nfet_01v8__model L=0.15U W=0.54U AS=0.1566P AD=0.1566P PS=1.66U PD=1.66U
Mtr_00008 125 16 93 122 sky130_fd_pr__nfet_01v8__model L=0.15U W=0.54U AS=0.1566P AD=0.1566P PS=1.66U PD=1.66U
Mtr_00007 54 35 125 122 sky130_fd_pr__nfet_01v8__model L=0.15U W=0.54U AS=0.1566P AD=0.1566P PS=1.66U PD=1.66U
Mtr_00006 38 21 127 122 sky130_fd_pr__nfet_01v8__model L=0.15U W=0.42U AS=0.1218P AD=0.1218P PS=1.42U PD=1.42U
Mtr_00005 123 70 131 122 sky130_fd_pr__nfet_01v8__model L=0.15U W=0.42U AS=0.1218P AD=0.1218P PS=1.42U PD=1.42U
Mtr_00004 100 63 91 122 sky130_fd_pr__nfet_01v8__model L=0.15U W=0.54U AS=0.1566P AD=0.1566P PS=1.66U PD=1.66U
Mtr_00003 97 71 103 122 sky130_fd_pr__nfet_01v8__model L=0.15U W=0.54U AS=0.1566P AD=0.1566P PS=1.66U PD=1.66U
Mtr_00002 103 133 100 122 sky130_fd_pr__nfet_01v8__model L=0.15U W=0.54U AS=0.1566P AD=0.1566P PS=1.66U PD=1.66U
Mtr_00001 93 58 97 122 sky130_fd_pr__nfet_01v8__model L=0.15U W=0.54U AS=0.1566P AD=0.1566P PS=1.66U PD=1.66U
R17_1 9 7 15
R17_2 10 8 15
R17_3 9 10 104
C17_31 9 122 2.4644e-16
C17_32 10 122 2.4644e-16
R15_1 22 17 15
R15_2 21 23 576
C15_21 21 122 1.0389e-16
C15_22 23 122 1.0389e-16
R15_3 22 23 528
C15_31 22 122 9.01992e-17
C15_32 23 122 9.01992e-17
R15_4 25 24 48
C15_41 25 122 1.28856e-17
C15_42 24 122 1.28856e-17
R15_5 22 25 384
C15_51 22 122 6.4428e-17
C15_52 25 122 6.4428e-17
R15_6 18 22 336
C15_61 18 122 5.79852e-17
C15_62 22 122 5.79852e-17
R15_7 16 19 48
C15_71 16 122 1.28856e-17
C15_72 19 122 1.28856e-17
R15_8 20 18 48
C15_81 20 122 1.28856e-17
C15_82 18 122 1.28856e-17
R15_9 19 20 192
C15_91 19 122 3.86568e-17
C15_92 20 122 3.86568e-17
R14_1 30 29 15
R14_2 31 29 15
R14_3 28 30 528
C14_31 28 122 9.34206e-17
C14_32 30 122 9.34206e-17
R13_1 42 38 15
R13_2 44 43 15
R13_3 35 36 15
R13_4 40 39 15
R13_5 46 45 48
C13_51 46 122 1.28856e-17
C13_52 45 122 1.28856e-17
R13_6 40 46 720
C13_61 40 122 1.22413e-16
C13_62 46 122 1.22413e-16
R13_7 34 39 13
C13_71 34 122 5.3574e-17
C13_72 39 122 5.3574e-17
R13_8 36 37 13
C13_81 36 122 4.28592e-17
C13_82 37 122 4.28592e-17
R13_9 34 36 26
C13_91 34 122 8.57184e-17
C13_92 36 122 8.57184e-17
R13_10 37 41 13
C13_101 37 122 5.3574e-17
C13_102 41 122 5.3574e-17
R13_11 41 42 26
C13_111 41 122 5.89314e-17
C13_112 42 122 5.89314e-17
R13_12 42 44 52
C13_121 42 122 1.39292e-16
C13_122 44 122 1.39292e-16
R12_1 50 49 7.5
R12_2 50 51 3.75
R10_1 59 57 15
R10_2 59 60 768
C10_21 59 122 1.28856e-16
C10_22 60 122 1.28856e-16
R10_3 58 59 528
C10_31 58 122 9.34206e-17
C10_32 59 122 9.34206e-17
R9_1 65 64 15
R9_2 65 66 768
C9_21 65 122 1.28856e-16
C9_22 66 122 1.28856e-16
R9_3 63 65 528
C9_31 63 122 9.34206e-17
C9_32 65 122 9.34206e-17
R8_1 78 79 15
R8_2 73 69 15
R8_3 73 72 288
C8_31 73 122 4.8321e-17
C8_32 72 122 4.8321e-17
R8_4 70 73 288
C8_41 70 122 5.15424e-17
C8_42 73 122 5.15424e-17
R8_5 69 79 52
C8_51 69 122 1.28578e-16
C8_52 79 122 1.28578e-16
R8_6 74 78 528
C8_61 74 122 9.50313e-17
C8_62 78 122 9.50313e-17
R8_7 74 75 48
C8_71 74 122 1.28856e-17
C8_72 75 122 1.28856e-17
R8_8 76 75 288
C8_81 76 122 5.15424e-17
C8_82 75 122 5.15424e-17
R8_9 76 77 192
C8_91 76 122 3.2214e-17
C8_92 77 122 3.2214e-17
R8_10 71 77 384
C8_101 71 122 6.76494e-17
C8_102 77 122 6.76494e-17
R7_1 85 82 15
R7_2 86 84 15
R7_3 87 83 15
R7_4 87 88 26
C7_41 87 122 6.42888e-17
C7_42 88 122 6.42888e-17
R7_5 86 88 26
C7_51 86 122 6.42888e-17
C7_52 88 122 6.42888e-17
R7_6 85 88 26
C7_61 85 122 6.42888e-17
C7_62 88 122 6.42888e-17
R6_1 92 91 15
R6_2 94 93 15
R6_3 92 94 104
C6_31 92 122 2.4644e-16
C6_32 94 122 2.4644e-16
R3_1 104 103 15
R3_2 118 117 15
R3_3 115 114 15
R3_4 113 112 15
R3_5 108 106 15
R3_6 113 111 528
C3_61 113 122 9.34206e-17
C3_62 111 122 9.34206e-17
R3_7 109 113 432
C3_71 109 122 7.40922e-17
C3_72 113 122 7.40922e-17
R3_8 108 107 13
C3_81 108 122 5.3574e-17
C3_82 107 122 5.3574e-17
R3_9 107 110 26
C3_91 107 122 6.42888e-17
C3_92 110 122 6.42888e-17
R3_10 112 119 78
C3_101 112 122 1.92866e-16
C3_102 119 122 1.92866e-16
R3_11 110 112 39
C3_111 110 122 1.07148e-16
C3_112 112 122 1.07148e-16
R3_12 118 119 26
C3_121 118 122 7.50036e-17
C3_122 119 122 7.50036e-17
R3_13 116 118 91
C3_131 116 122 2.25011e-16
C3_132 118 122 2.25011e-16
R3_14 115 116 26
C3_141 115 122 7.50036e-17
C3_142 116 122 7.50036e-17
R3_15 105 116 130
C3_151 105 122 3.00014e-16
C3_152 116 122 3.00014e-16
R3_16 104 105 26
C3_161 104 122 7.50036e-17
C3_162 105 122 7.50036e-17
R2_1 124 123 15
R2_2 126 125 15
R2_3 128 127 15
R2_4 122 128 26
C2_41 122 122 6.42888e-17
C2_42 128 122 6.42888e-17
R2_5 122 126 26
C2_51 122 122 6.42888e-17
C2_52 126 122 6.42888e-17
R2_6 122 124 26
C2_61 122 122 6.42888e-17
C2_62 124 122 6.42888e-17
R1_1 132 131 15
R1_2 133 134 15
R1_3 136 135 15
R1_4 138 139 15
R1_5 137 139 13
C1_51 137 122 5.3574e-17
C1_52 139 122 5.3574e-17
R1_6 136 137 65
C1_61 136 122 1.50007e-16
C1_62 137 122 1.50007e-16
R1_7 132 136 65
C1_71 132 122 1.71437e-16
C1_72 136 122 1.71437e-16
R1_8 132 134 26
C1_81 132 122 7.50036e-17
C1_82 134 122 7.50036e-17
.ends mx3_x2
