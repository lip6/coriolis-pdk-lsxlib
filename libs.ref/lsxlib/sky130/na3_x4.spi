* Spice description of na3_x4
* Spice driver version 936836013
* Date ( dd/mm/yyyy hh:mm:ss ):  8/05/2026 at 14:22:51

* INTERF i0 i1 i2 nq vdd vss

.subckt na3_x4 30 24 17 65 46 55
* NET 17 = i2
* NET 24 = i1
* NET 30 = i0
* NET 46 = vdd
* NET 55 = vss
* NET 65 = nq
Mtr_00012 37 85 11 46 sky130_fd_pr__pfet_01v8__model L=0.15U W=1.26U AS=0.3654P AD=0.3654P PS=3.1U PD=3.1U
Mtr_00011 81 27 41 46 sky130_fd_pr__pfet_01v8__model L=0.15U W=1.02U AS=0.2958P AD=0.2958P PS=2.62U PD=2.62U
Mtr_00010 79 33 41 46 sky130_fd_pr__pfet_01v8__model L=0.15U W=1.02U AS=0.2958P AD=0.2958P PS=2.62U PD=2.62U
Mtr_00009 36 21 81 46 sky130_fd_pr__pfet_01v8__model L=0.15U W=1.02U AS=0.2958P AD=0.2958P PS=2.62U PD=2.62U
Mtr_00008 36 7 66 46 sky130_fd_pr__pfet_01v8__model L=0.15U W=2.46U AS=0.7134P AD=0.7134P PS=5.5U PD=5.5U
Mtr_00007 66 8 37 46 sky130_fd_pr__pfet_01v8__model L=0.15U W=2.46U AS=0.7134P AD=0.7134P PS=5.5U PD=5.5U
Mtr_00006 3 72 58 55 sky130_fd_pr__nfet_01v8__model L=0.15U W=0.66U AS=0.1914P AD=0.1914P PS=1.9U PD=1.9U
Mtr_00005 49 31 69 55 sky130_fd_pr__nfet_01v8__model L=0.15U W=1.5U AS=0.435P AD=0.435P PS=3.58U PD=3.58U
Mtr_00004 49 25 52 55 sky130_fd_pr__nfet_01v8__model L=0.15U W=1.5U AS=0.435P AD=0.435P PS=3.58U PD=3.58U
Mtr_00003 52 16 56 55 sky130_fd_pr__nfet_01v8__model L=0.15U W=1.5U AS=0.435P AD=0.435P PS=3.58U PD=3.58U
Mtr_00002 58 2 64 55 sky130_fd_pr__nfet_01v8__model L=0.15U W=1.26U AS=0.3654P AD=0.3654P PS=3.1U PD=3.1U
Mtr_00001 64 1 56 55 sky130_fd_pr__nfet_01v8__model L=0.15U W=1.26U AS=0.3654P AD=0.3654P PS=3.1U PD=3.1U
R10_1 10 9 15
R10_2 12 11 15
R10_3 13 11 15
R10_4 4 3 15
R10_5 6 5 15
R10_6 2 6 288
C10_61 2 55 5.15424e-17
C10_62 6 55 5.15424e-17
R10_7 1 2 192
C10_71 1 55 3.86568e-17
C10_72 2 55 3.86568e-17
R10_8 12 13 26
C10_81 12 55 7.50036e-17
C10_82 13 55 7.50036e-17
R10_9 9 12 52
C10_91 9 55 1.39292e-16
C10_92 12 55 1.39292e-16
R10_10 5 9 26
C10_101 5 55 8.57184e-17
C10_102 9 55 8.57184e-17
R10_11 4 5 39
C10_111 4 55 1.07148e-16
C10_112 5 55 1.07148e-16
R10_12 8 10 288
C10_121 8 55 5.15424e-17
C10_122 10 55 5.15424e-17
R10_13 7 8 192
C10_131 7 55 3.86568e-17
C10_132 8 55 3.86568e-17
R9_1 18 17 15
R9_2 20 21 672
C9_21 20 55 1.12749e-16
C9_22 21 55 1.12749e-16
R9_3 19 20 48
C9_31 19 55 1.28856e-17
C9_32 20 55 1.28856e-17
R9_4 18 19 144
C9_41 18 55 2.57712e-17
C9_42 19 55 2.57712e-17
R9_5 16 18 336
C9_51 16 55 6.12066e-17
C9_52 18 55 6.12066e-17
R8_1 26 24 15
R8_2 26 27 816
C8_21 26 55 1.3852e-16
C8_22 27 55 1.3852e-16
R8_3 25 26 336
C8_31 25 55 6.12066e-17
C8_32 26 55 6.12066e-17
R7_1 32 30 15
R7_2 32 33 816
C7_21 32 55 1.3852e-16
C7_22 33 55 1.3852e-16
R7_3 31 32 336
C7_31 31 55 6.12066e-17
C7_32 32 55 6.12066e-17
R6_1 44 36 15
R6_2 42 36 15
R6_3 40 37 15
R6_4 39 37 15
R6_5 45 37 15
R6_6 38 37 15
R6_7 43 41 15
R6_8 43 46 26
C6_81 43 55 6.42888e-17
C6_82 46 55 6.42888e-17
R6_9 45 46 26
C6_91 45 55 6.42888e-17
C6_92 46 55 6.42888e-17
R6_10 40 45 26
C6_101 40 55 6.42888e-17
C6_102 45 55 6.42888e-17
R6_11 39 40 26
C6_111 39 55 6.42888e-17
C6_112 40 55 6.42888e-17
R6_12 38 39 13
C6_121 38 55 5.3574e-17
C6_122 39 55 5.3574e-17
R6_13 44 46 26
C6_131 44 55 6.42888e-17
C6_132 46 55 6.42888e-17
R6_14 42 44 13
C6_141 42 55 5.3574e-17
C6_142 44 55 5.3574e-17
R3_1 57 56 15
R3_2 60 56 15
R3_3 61 58 15
R3_4 59 58 15
R3_5 59 61 26
C3_51 59 55 7.50036e-17
C3_52 61 55 7.50036e-17
R3_6 55 59 26
C3_61 55 55 6.42888e-17
C3_62 59 55 6.42888e-17
R3_7 57 60 13
C3_71 57 55 4.28592e-17
C3_72 60 55 4.28592e-17
R3_8 55 57 26
C3_81 55 55 6.42888e-17
C3_82 57 55 6.42888e-17
R2_1 64 65 7.5
R2_2 65 66 3.75
R1_1 70 69 15
R1_2 77 76 15
R1_3 88 81 15
R1_4 83 81 15
R1_5 80 79 15
R1_6 87 79 15
R1_7 72 73 192
C1_71 72 55 3.86568e-17
C1_72 73 55 3.86568e-17
R1_8 85 86 192
C1_81 85 55 3.86568e-17
C1_82 86 55 3.86568e-17
R1_9 80 87 13
C1_91 80 55 5.3574e-17
C1_92 87 55 5.3574e-17
R1_10 78 86 528
C1_101 78 55 9.01992e-17
C1_102 86 55 9.01992e-17
R1_11 73 78 336
C1_111 73 55 5.79852e-17
C1_112 78 55 5.79852e-17
R1_12 80 83 52
C1_121 80 55 1.28578e-16
C1_122 83 55 1.28578e-16
R1_13 77 78 768
C1_131 77 55 1.35299e-16
C1_132 78 55 1.35299e-16
R1_14 83 88 13
C1_141 83 55 5.3574e-17
C1_142 88 55 5.3574e-17
R1_15 82 83 13
C1_151 82 55 5.3574e-17
C1_152 83 55 5.3574e-17
R1_16 82 84 26
C1_161 82 55 6.42888e-17
C1_162 84 55 6.42888e-17
R1_17 76 84 65
C1_171 76 55 1.50007e-16
C1_172 84 55 1.50007e-16
R1_18 75 76 13
C1_181 75 55 5.3574e-17
C1_182 76 55 5.3574e-17
R1_19 74 75 26
C1_191 74 55 6.42888e-17
C1_192 75 55 6.42888e-17
R1_20 71 74 39
C1_201 71 55 9.64332e-17
C1_202 74 55 9.64332e-17
R1_21 70 71 52
C1_211 70 55 1.28578e-16
C1_212 71 55 1.28578e-16
.ends na3_x4
