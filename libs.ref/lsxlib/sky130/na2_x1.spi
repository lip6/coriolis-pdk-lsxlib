* Spice description of na2_x1
* Spice driver version -1851331667
* Date ( dd/mm/yyyy hh:mm:ss ):  8/05/2026 at 14:22:51

* INTERF i0 i1 nq vdd vss

.subckt na2_x1 8 15 25 5 20
* NET 5 = vdd
* NET 8 = i0
* NET 15 = i1
* NET 20 = vss
* NET 25 = nq
Mtr_00004 2 17 28 5 sky130_fd_pr__pfet_01v8__model L=0.15U W=1.26U AS=0.3654P AD=0.3654P PS=3.1U PD=3.1U
Mtr_00003 28 11 1 5 sky130_fd_pr__pfet_01v8__model L=0.15U W=1.26U AS=0.3654P AD=0.3654P PS=3.1U PD=3.1U
Mtr_00002 31 14 26 20 sky130_fd_pr__nfet_01v8__model L=0.15U W=1.26U AS=0.3654P AD=0.3654P PS=3.1U PD=3.1U
Mtr_00001 21 9 31 20 sky130_fd_pr__nfet_01v8__model L=0.15U W=1.26U AS=0.3654P AD=0.3654P PS=3.1U PD=3.1U
R6_1 3 1 15
R6_2 4 2 15
R6_3 4 5 26
C6_31 4 20 6.42888e-17
C6_32 5 20 6.42888e-17
R6_4 3 5 26
C6_41 3 20 6.42888e-17
C6_42 5 20 6.42888e-17
R5_1 10 8 15
R5_2 10 11 576
C5_21 10 20 9.98634e-17
C5_22 11 20 9.98634e-17
R5_3 9 10 576
C5_31 9 20 9.98634e-17
C5_32 10 20 9.98634e-17
R4_1 16 15 15
R4_2 16 17 576
C4_21 16 20 9.98634e-17
C4_22 17 20 9.98634e-17
R4_3 14 16 576
C4_31 14 20 9.98634e-17
C4_32 16 20 9.98634e-17
R3_1 21 22 15
R3_2 20 22 26
C3_21 20 20 6.42888e-17
C3_22 22 20 6.42888e-17
R2_1 26 27 15
R2_2 25 28 7.5
R2_3 25 27 26
C2_31 25 20 6.42888e-17
C2_32 27 20 6.42888e-17
.ends na2_x1
