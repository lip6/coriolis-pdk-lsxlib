* Spice description of noa2a2a2a24_x4
* Spice driver version 685616045
* Date ( dd/mm/yyyy hh:mm:ss ):  8/05/2026 at 14:22:51

* INTERF i0 i1 i2 i3 i4 i5 i6 i7 nq vdd vss

.subckt noa2a2a2a24_x4 102 108 91 96 60 66 78 72 42 38 133
* NET 38 = vdd
* NET 42 = nq
* NET 60 = i4
* NET 66 = i5
* NET 72 = i7
* NET 78 = i6
* NET 91 = i2
* NET 96 = i3
* NET 102 = i0
* NET 108 = i1
* NET 133 = vss
Mtr_00022 32 105 16 38 sky130_fd_pr__pfet_01v8__model L=0.15U W=1.26U AS=0.3654P AD=0.3654P PS=3.1U PD=3.1U
Mtr_00021 3 69 11 38 sky130_fd_pr__pfet_01v8__model L=0.15U W=1.26U AS=0.3654P AD=0.3654P PS=3.1U PD=3.1U
Mtr_00020 10 99 17 38 sky130_fd_pr__pfet_01v8__model L=0.15U W=1.26U AS=0.3654P AD=0.3654P PS=3.1U PD=3.1U
Mtr_00019 18 93 10 38 sky130_fd_pr__pfet_01v8__model L=0.15U W=1.26U AS=0.3654P AD=0.3654P PS=3.1U PD=3.1U
Mtr_00018 17 111 32 38 sky130_fd_pr__pfet_01v8__model L=0.15U W=1.26U AS=0.3654P AD=0.3654P PS=3.1U PD=3.1U
Mtr_00017 11 63 1 38 sky130_fd_pr__pfet_01v8__model L=0.15U W=1.26U AS=0.3654P AD=0.3654P PS=3.1U PD=3.1U
Mtr_00016 124 81 3 38 sky130_fd_pr__pfet_01v8__model L=0.15U W=1.26U AS=0.3654P AD=0.3654P PS=3.1U PD=3.1U
Mtr_00015 5 75 124 38 sky130_fd_pr__pfet_01v8__model L=0.15U W=1.26U AS=0.3654P AD=0.3654P PS=3.1U PD=3.1U
Mtr_00014 43 53 26 38 sky130_fd_pr__pfet_01v8__model L=0.15U W=2.46U AS=0.7134P AD=0.7134P PS=5.5U PD=5.5U
Mtr_00013 28 54 43 38 sky130_fd_pr__pfet_01v8__model L=0.15U W=2.46U AS=0.7134P AD=0.7134P PS=5.5U PD=5.5U
Mtr_00012 55 126 26 38 sky130_fd_pr__pfet_01v8__model L=0.15U W=1.26U AS=0.3654P AD=0.3654P PS=3.1U PD=3.1U
Mtr_00011 114 97 150 133 sky130_fd_pr__nfet_01v8__model L=0.15U W=0.66U AS=0.1914P AD=0.1914P PS=1.9U PD=1.9U
Mtr_00010 130 109 114 133 sky130_fd_pr__nfet_01v8__model L=0.15U W=0.66U AS=0.1914P AD=0.1914P PS=1.9U PD=1.9U
Mtr_00009 134 103 130 133 sky130_fd_pr__nfet_01v8__model L=0.15U W=0.66U AS=0.1914P AD=0.1914P PS=1.9U PD=1.9U
Mtr_00008 87 73 140 133 sky130_fd_pr__nfet_01v8__model L=0.15U W=0.66U AS=0.1914P AD=0.1914P PS=1.9U PD=1.9U
Mtr_00007 117 79 87 133 sky130_fd_pr__nfet_01v8__model L=0.15U W=0.66U AS=0.1914P AD=0.1914P PS=1.9U PD=1.9U
Mtr_00006 84 67 117 133 sky130_fd_pr__nfet_01v8__model L=0.15U W=0.66U AS=0.1914P AD=0.1914P PS=1.9U PD=1.9U
Mtr_00005 137 61 84 133 sky130_fd_pr__nfet_01v8__model L=0.15U W=0.66U AS=0.1914P AD=0.1914P PS=1.9U PD=1.9U
Mtr_00004 150 90 136 133 sky130_fd_pr__nfet_01v8__model L=0.15U W=0.66U AS=0.1914P AD=0.1914P PS=1.9U PD=1.9U
Mtr_00003 41 49 144 133 sky130_fd_pr__nfet_01v8__model L=0.15U W=1.26U AS=0.3654P AD=0.3654P PS=3.1U PD=3.1U
Mtr_00002 142 120 46 133 sky130_fd_pr__nfet_01v8__model L=0.15U W=0.66U AS=0.1914P AD=0.1914P PS=1.9U PD=1.9U
Mtr_00001 142 48 41 133 sky130_fd_pr__nfet_01v8__model L=0.15U W=1.26U AS=0.3654P AD=0.3654P PS=3.1U PD=3.1U
R20_1 2 1 15
R20_2 4 3 15
R20_3 6 3 15
R20_4 7 5 15
R20_5 6 7 52
C20_51 6 133 1.28578e-16
C20_52 7 133 1.28578e-16
R20_6 4 6 13
C20_61 4 133 5.3574e-17
C20_62 6 133 5.3574e-17
R20_7 2 4 52
C20_71 2 133 1.28578e-16
C20_72 4 133 1.28578e-16
R19_1 12 10 15
R19_2 13 11 15
R19_3 12 13 78
C19_31 12 133 1.92866e-16
C19_32 13 133 1.92866e-16
R18_1 20 17 15
R18_2 23 17 15
R18_3 21 18 15
R18_4 19 16 15
R18_5 22 16 15
R18_6 19 22 13
C18_61 19 133 5.3574e-17
C18_62 22 133 5.3574e-17
R18_7 20 23 13
C18_71 20 133 5.3574e-17
C18_72 23 133 5.3574e-17
R18_8 20 21 52
C18_81 20 133 1.28578e-16
C18_82 21 133 1.28578e-16
R18_9 19 20 52
C18_91 19 133 1.28578e-16
C18_92 20 133 1.28578e-16
R17_1 30 26 15
R17_2 36 26 15
R17_3 33 26 15
R17_4 26 27 15
R17_5 34 28 15
R17_6 37 28 15
R17_7 31 28 15
R17_8 29 28 15
R17_9 35 32 15
R17_10 35 38 26
C17_101 35 133 6.42888e-17
C17_102 38 133 6.42888e-17
R17_11 37 38 26
C17_111 37 133 6.42888e-17
C17_112 38 133 6.42888e-17
R17_12 34 37 13
C17_121 34 133 5.3574e-17
C17_122 37 133 5.3574e-17
R17_13 31 34 26
C17_131 31 133 6.42888e-17
C17_132 34 133 6.42888e-17
R17_14 29 31 26
C17_141 29 133 6.42888e-17
C17_142 31 133 6.42888e-17
R17_15 36 38 26
C17_151 36 133 6.42888e-17
C17_152 38 133 6.42888e-17
R17_16 33 36 13
C17_161 33 133 5.3574e-17
C17_162 36 133 5.3574e-17
R17_17 30 33 26
C17_171 30 133 6.42888e-17
C17_172 33 133 6.42888e-17
R17_18 27 30 26
C17_181 27 133 6.42888e-17
C17_182 30 133 6.42888e-17
R16_1 42 41 7.5
R16_2 42 43 3.75
R15_1 47 46 15
R15_2 56 55 15
R15_3 57 55 15
R15_4 52 51 15
R15_5 52 54 528
C15_51 52 133 9.34206e-17
C15_52 54 133 9.34206e-17
R15_6 49 52 432
C15_61 49 133 7.40922e-17
C15_62 52 133 7.40922e-17
R15_7 52 53 528
C15_71 52 133 9.34206e-17
C15_72 53 133 9.34206e-17
R15_8 48 52 432
C15_81 48 133 7.40922e-17
C15_82 52 133 7.40922e-17
R15_9 50 51 26
C15_91 50 133 7.50036e-17
C15_92 51 133 7.50036e-17
R15_10 56 57 13
C15_101 56 133 5.3574e-17
C15_102 57 133 5.3574e-17
R15_11 50 56 78
C15_111 50 133 1.92866e-16
C15_112 56 133 1.92866e-16
R15_12 47 50 65
C15_121 47 133 1.60722e-16
C15_122 50 133 1.60722e-16
R14_1 62 60 15
R14_2 62 63 720
C14_21 62 133 1.25635e-16
C14_22 63 133 1.25635e-16
R14_3 61 62 528
C14_31 61 133 9.01992e-17
C14_32 62 133 9.01992e-17
R13_1 68 66 15
R13_2 68 69 720
C13_21 68 133 1.25635e-16
C13_22 69 133 1.25635e-16
R13_3 67 68 528
C13_31 67 133 9.01992e-17
C13_32 68 133 9.01992e-17
R12_1 74 72 15
R12_2 74 75 720
C12_21 74 133 1.25635e-16
C12_22 75 133 1.25635e-16
R12_3 73 74 528
C12_31 73 133 9.01992e-17
C12_32 74 133 9.01992e-17
R11_1 80 78 15
R11_2 80 81 720
C11_21 80 133 1.25635e-16
C11_22 81 133 1.25635e-16
R11_3 79 80 528
C11_31 79 133 9.01992e-17
C11_32 80 133 9.01992e-17
R8_1 92 91 15
R8_2 92 93 720
C8_21 92 133 1.25635e-16
C8_22 93 133 1.25635e-16
R8_3 90 92 528
C8_31 90 133 9.01992e-17
C8_32 92 133 9.01992e-17
R7_1 98 96 15
R7_2 98 99 720
C7_21 98 133 1.25635e-16
C7_22 99 133 1.25635e-16
R7_3 97 98 528
C7_31 97 133 9.01992e-17
C7_32 98 133 9.01992e-17
R6_1 104 102 15
R6_2 104 105 720
C6_21 104 133 1.25635e-16
C6_22 105 133 1.25635e-16
R6_3 103 104 528
C6_31 103 133 9.01992e-17
C6_32 104 133 9.01992e-17
R5_1 110 108 15
R5_2 110 111 720
C5_21 110 133 1.25635e-16
C5_22 111 133 1.25635e-16
R5_3 109 110 528
C5_31 109 133 9.01992e-17
C5_32 110 133 9.01992e-17
R4_1 115 114 15
R4_2 123 122 15
R4_3 118 117 15
R4_4 125 124 15
R4_5 123 126 720
C4_51 123 133 1.25635e-16
C4_52 126 133 1.25635e-16
R4_6 120 123 528
C4_61 120 133 9.01992e-17
C4_62 123 133 9.01992e-17
R4_7 125 127 26
C4_71 125 133 7.50036e-17
C4_72 127 133 7.50036e-17
R4_8 118 119 13
C4_81 118 133 5.3574e-17
C4_82 119 133 5.3574e-17
R4_9 122 127 78
C4_91 122 133 1.92866e-16
C4_92 127 133 1.92866e-16
R4_10 121 122 39
C4_101 121 133 1.07148e-16
C4_102 122 133 1.07148e-16
R4_11 119 121 52
C4_111 119 133 1.39292e-16
C4_112 121 133 1.39292e-16
R4_12 116 119 130
C4_121 116 133 3.21444e-16
C4_122 119 133 3.21444e-16
R4_13 115 116 13
C4_131 115 133 5.3574e-17
C4_132 116 133 5.3574e-17
R2_1 138 136 15
R2_2 147 144 15
R2_3 145 144 15
R2_4 146 142 15
R2_5 143 142 15
R2_6 139 137 15
R2_7 141 140 15
R2_8 135 134 15
R2_9 133 135 26
C2_91 133 133 6.42888e-17
C2_92 135 133 6.42888e-17
R2_10 133 141 26
C2_101 133 133 6.42888e-17
C2_102 141 133 6.42888e-17
R2_11 133 139 26
C2_111 133 133 6.42888e-17
C2_112 139 133 6.42888e-17
R2_12 143 146 26
C2_121 143 133 7.50036e-17
C2_122 146 133 7.50036e-17
R2_13 133 143 26
C2_131 133 133 6.42888e-17
C2_132 143 133 6.42888e-17
R2_14 145 147 26
C2_141 145 133 7.50036e-17
C2_142 147 133 7.50036e-17
R2_15 133 145 26
C2_151 133 133 6.42888e-17
C2_152 145 133 6.42888e-17
R2_16 133 138 26
C2_161 133 133 6.42888e-17
C2_162 138 133 6.42888e-17
.ends noa2a2a2a24_x4
