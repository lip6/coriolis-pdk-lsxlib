* Spice description of mx2_x2
* Spice driver version -1848636499
* Date ( dd/mm/yyyy hh:mm:ss ):  8/05/2026 at 14:22:52

* INTERF cmd i0 i1 q vdd vss

.subckt mx2_x2 42 31 22 18 14 87
* NET 14 = vdd
* NET 18 = q
* NET 22 = i1
* NET 31 = i0
* NET 42 = cmd
* NET 87 = vss
Mtr_00012 19 79 7 14 sky130_fd_pr__pfet_01v8__model L=0.15U W=2.46U AS=0.7134P AD=0.7134P PS=5.5U PD=5.5U
Mtr_00011 1 26 7 14 sky130_fd_pr__pfet_01v8__model L=0.15U W=1.26U AS=0.3654P AD=0.3654P PS=3.1U PD=3.1U
Mtr_00010 63 45 10 14 sky130_fd_pr__pfet_01v8__model L=0.15U W=1.02U AS=0.2958P AD=0.2958P PS=2.62U PD=2.62U
Mtr_00009 10 34 4 14 sky130_fd_pr__pfet_01v8__model L=0.15U W=1.26U AS=0.3654P AD=0.3654P PS=3.1U PD=3.1U
Mtr_00008 80 61 1 14 sky130_fd_pr__pfet_01v8__model L=0.15U W=1.26U AS=0.3654P AD=0.3654P PS=3.1U PD=3.1U
Mtr_00007 4 47 80 14 sky130_fd_pr__pfet_01v8__model L=0.15U W=1.26U AS=0.3654P AD=0.3654P PS=3.1U PD=3.1U
Mtr_00006 90 24 84 87 sky130_fd_pr__nfet_01v8__model L=0.15U W=0.66U AS=0.1914P AD=0.1914P PS=1.9U PD=1.9U
Mtr_00005 17 73 90 87 sky130_fd_pr__nfet_01v8__model L=0.15U W=1.26U AS=0.3654P AD=0.3654P PS=3.1U PD=3.1U
Mtr_00004 88 38 54 87 sky130_fd_pr__nfet_01v8__model L=0.15U W=0.54U AS=0.1566P AD=0.1566P PS=1.66U PD=1.66U
Mtr_00003 84 39 71 87 sky130_fd_pr__nfet_01v8__model L=0.15U W=0.66U AS=0.1914P AD=0.1914P PS=1.9U PD=1.9U
Mtr_00002 51 30 88 87 sky130_fd_pr__nfet_01v8__model L=0.15U W=0.66U AS=0.1914P AD=0.1914P PS=1.9U PD=1.9U
Mtr_00001 71 58 51 87 sky130_fd_pr__nfet_01v8__model L=0.15U W=0.66U AS=0.1914P AD=0.1914P PS=1.9U PD=1.9U
R10_1 7 8 15
R10_2 9 7 15
R10_3 13 7 15
R10_4 11 7 15
R10_5 12 10 15
R10_6 12 14 26
C10_61 12 87 6.42888e-17
C10_62 14 87 6.42888e-17
R10_7 13 14 26
C10_71 13 87 6.42888e-17
C10_72 14 87 6.42888e-17
R10_8 11 13 26
C10_81 11 87 6.42888e-17
C10_82 13 87 6.42888e-17
R10_9 9 11 26
C10_91 9 87 6.42888e-17
C10_92 11 87 6.42888e-17
R10_10 8 9 13
C10_101 8 87 5.3574e-17
C10_102 9 87 5.3574e-17
R9_1 18 17 7.5
R9_2 18 19 3.75
R8_1 25 22 15
R8_2 23 22 15
R8_3 24 23 336
C8_31 24 87 5.79852e-17
C8_32 23 87 5.79852e-17
R8_4 25 26 480
C8_41 25 87 8.0535e-17
C8_42 26 87 8.0535e-17
R7_1 32 31 15
R7_2 33 31 15
R7_3 35 34 288
C7_31 35 87 4.8321e-17
C7_32 34 87 4.8321e-17
R7_4 33 35 96
C7_41 33 87 1.93284e-17
C7_42 35 87 1.93284e-17
R7_5 29 30 48
C7_51 29 87 1.28856e-17
C7_52 30 87 1.28856e-17
R7_6 29 32 192
C7_61 29 87 3.2214e-17
C7_62 32 87 3.2214e-17
R6_1 43 42 15
R6_2 40 39 48
C6_21 40 87 1.28856e-17
C6_22 39 87 1.28856e-17
R6_3 40 44 336
C6_31 40 87 5.79852e-17
C6_32 44 87 5.79852e-17
R6_4 41 45 768
C6_41 41 87 1.36104e-16
C6_42 45 87 1.36104e-16
R6_5 38 41 480
C6_51 38 87 8.45618e-17
C6_52 41 87 8.45618e-17
R6_6 48 47 480
C6_61 48 87 8.0535e-17
C6_62 47 87 8.0535e-17
R6_7 43 44 240
C6_71 43 87 4.50996e-17
C6_72 44 87 4.50996e-17
R6_8 41 43 336
C6_81 41 87 5.79852e-17
C6_82 43 87 5.79852e-17
R6_9 46 48 96
C6_91 46 87 1.93284e-17
C6_92 48 87 1.93284e-17
R6_10 43 46 240
C6_101 43 87 4.5905e-17
C6_102 46 87 4.5905e-17
R4_1 55 54 15
R4_2 66 63 15
R4_3 64 63 15
R4_4 60 59 15
R4_5 61 62 15
R4_6 58 60 336
C4_61 58 87 5.79852e-17
C4_62 60 87 5.79852e-17
R4_7 62 68 52
C4_71 62 87 1.17863e-16
C4_72 68 87 1.17863e-16
R4_8 67 68 52
C4_81 67 87 1.17863e-16
C4_82 68 87 1.17863e-16
R4_9 57 59 13
C4_91 57 87 5.3574e-17
C4_92 59 87 5.3574e-17
R4_10 65 67 13
C4_101 65 87 5.3574e-17
C4_102 67 87 5.3574e-17
R4_11 56 57 52
C4_111 56 87 1.28578e-16
C4_112 57 87 1.28578e-16
R4_12 64 65 52
C4_121 64 87 1.17863e-16
C4_122 65 87 1.17863e-16
R4_13 64 66 13
C4_131 64 87 5.3574e-17
C4_132 66 87 5.3574e-17
R4_14 56 64 130
C4_141 56 87 3.00014e-16
C4_142 64 87 3.00014e-16
R4_15 55 56 13
C4_151 55 87 5.3574e-17
C4_152 56 87 5.3574e-17
R3_1 72 71 15
R3_2 77 76 15
R3_3 81 80 15
R3_4 75 79 528
C3_41 75 87 9.34206e-17
C3_42 79 87 9.34206e-17
R3_5 73 75 432
C3_51 73 87 7.40922e-17
C3_52 75 87 7.40922e-17
R3_6 74 75 288
C3_61 74 87 5.15424e-17
C3_62 75 87 5.15424e-17
R3_7 74 78 96
C3_71 74 87 1.93284e-17
C3_72 78 87 1.93284e-17
R3_8 77 78 192
C3_81 77 87 3.86568e-17
C3_82 78 87 3.86568e-17
R3_9 76 81 65
C3_91 76 87 1.60722e-16
C3_92 81 87 1.60722e-16
R3_10 72 76 78
C3_101 72 87 1.92866e-16
C3_102 76 87 1.92866e-16
R1_1 89 88 15
R1_2 91 90 15
R1_3 92 90 15
R1_4 91 92 26
C1_41 91 87 7.50036e-17
C1_42 92 87 7.50036e-17
R1_5 87 91 26
C1_51 87 87 6.42888e-17
C1_52 91 87 6.42888e-17
R1_6 87 89 26
C1_61 87 87 6.42888e-17
C1_62 89 87 6.42888e-17
.ends mx2_x2
