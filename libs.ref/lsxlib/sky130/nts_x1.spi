* Spice description of nts_x1
* Spice driver version -1430983763
* Date ( dd/mm/yyyy hh:mm:ss ):  8/05/2026 at 14:23:17

* INTERF cmd i nq vdd vss

.subckt nts_x1 1 8 42 17 33
* NET 1 = cmd
* NET 8 = i
* NET 17 = vdd
* NET 33 = vss
* NET 42 = nq
Mtr_00006 43 11 20 17 sky130_fd_pr__pfet_01v8__model L=0.15U W=2.46U AS=0.7134P AD=0.7134P PS=5.5U PD=5.5U
Mtr_00005 20 27 14 17 sky130_fd_pr__pfet_01v8__model L=0.15U W=2.46U AS=0.7134P AD=0.7134P PS=5.5U PD=5.5U
Mtr_00004 28 5 14 17 sky130_fd_pr__pfet_01v8__model L=0.15U W=1.26U AS=0.3654P AD=0.3654P PS=3.1U PD=3.1U
Mtr_00003 41 9 38 33 sky130_fd_pr__nfet_01v8__model L=0.15U W=1.26U AS=0.3654P AD=0.3654P PS=3.1U PD=3.1U
Mtr_00002 38 4 34 33 sky130_fd_pr__nfet_01v8__model L=0.15U W=1.26U AS=0.3654P AD=0.3654P PS=3.1U PD=3.1U
Mtr_00001 34 2 23 33 sky130_fd_pr__nfet_01v8__model L=0.15U W=0.66U AS=0.1914P AD=0.1914P PS=1.9U PD=1.9U
R8_1 3 1 15
R8_2 5 1 15
R8_3 2 3 336
C8_31 2 33 5.79852e-17
C8_32 3 33 5.79852e-17
R8_4 3 4 240
C8_41 3 33 4.26836e-17
C8_42 4 33 4.26836e-17
R7_1 10 8 15
R7_2 10 11 576
C7_21 10 33 9.98634e-17
C7_22 11 33 9.98634e-17
R7_3 9 10 384
C7_31 9 33 6.76494e-17
C7_32 10 33 6.76494e-17
R6_1 14 16 15
R6_2 14 15 15
R6_3 16 17 26
C6_31 16 33 6.42888e-17
C6_32 17 33 6.42888e-17
R6_4 15 16 13
C6_41 15 33 4.28592e-17
C6_42 16 33 4.28592e-17
R4_1 23 24 15
R4_2 30 28 15
R4_3 29 28 15
R4_4 26 25 15
R4_5 26 27 384
C4_51 26 33 7.08708e-17
C4_52 27 33 7.08708e-17
R4_6 29 30 26
C4_61 29 33 7.50036e-17
C4_62 30 33 7.50036e-17
R4_7 25 29 52
C4_71 25 33 1.39292e-16
C4_72 29 33 1.39292e-16
R4_8 24 25 78
C4_81 24 33 1.92866e-16
C4_82 25 33 1.92866e-16
R3_1 34 35 15
R3_2 33 35 26
C3_21 33 33 6.42888e-17
C3_22 35 33 6.42888e-17
R1_1 42 41 7.5
R1_2 42 43 3.75
.ends nts_x1
