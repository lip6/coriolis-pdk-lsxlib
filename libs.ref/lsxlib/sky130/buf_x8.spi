* Spice description of buf_x8
* Spice driver version -1150755923
* Date ( dd/mm/yyyy hh:mm:ss ):  8/05/2026 at 14:22:51

* INTERF i q vdd vss

.subckt buf_x8 1 57 20 44
* NET 1 = i
* NET 20 = vdd
* NET 44 = vss
* NET 57 = q
Mtr_00010 7 4 37 20 sky130_fd_pr__pfet_01v8__model L=0.15U W=2.46U AS=0.7134P AD=0.7134P PS=5.5U PD=5.5U
Mtr_00009 10 36 63 20 sky130_fd_pr__pfet_01v8__model L=0.15U W=2.46U AS=0.7134P AD=0.7134P PS=5.5U PD=5.5U
Mtr_00008 63 35 8 20 sky130_fd_pr__pfet_01v8__model L=0.15U W=2.46U AS=0.7134P AD=0.7134P PS=5.5U PD=5.5U
Mtr_00007 8 34 61 20 sky130_fd_pr__pfet_01v8__model L=0.15U W=2.46U AS=0.7134P AD=0.7134P PS=5.5U PD=5.5U
Mtr_00006 61 33 7 20 sky130_fd_pr__pfet_01v8__model L=0.15U W=2.46U AS=0.7134P AD=0.7134P PS=5.5U PD=5.5U
Mtr_00005 23 2 45 44 sky130_fd_pr__nfet_01v8__model L=0.15U W=1.26U AS=0.3654P AD=0.3654P PS=3.1U PD=3.1U
Mtr_00004 58 30 49 44 sky130_fd_pr__nfet_01v8__model L=0.15U W=1.26U AS=0.3654P AD=0.3654P PS=3.1U PD=3.1U
Mtr_00003 47 29 58 44 sky130_fd_pr__nfet_01v8__model L=0.15U W=1.26U AS=0.3654P AD=0.3654P PS=3.1U PD=3.1U
Mtr_00002 55 28 47 44 sky130_fd_pr__nfet_01v8__model L=0.15U W=1.26U AS=0.3654P AD=0.3654P PS=3.1U PD=3.1U
Mtr_00001 45 27 55 44 sky130_fd_pr__nfet_01v8__model L=0.15U W=1.26U AS=0.3654P AD=0.3654P PS=3.1U PD=3.1U
R5_1 3 1 15
R5_2 3 4 480
C5_21 3 44 8.69778e-17
C5_22 4 44 8.69778e-17
R5_3 2 3 480
C5_31 2 44 8.0535e-17
C5_32 3 44 8.0535e-17
R4_1 14 8 15
R4_2 12 8 15
R4_3 18 8 15
R4_4 8 9 15
R4_5 13 10 15
R4_6 19 10 15
R4_7 15 10 15
R4_8 11 10 15
R4_9 17 7 15
R4_10 16 7 15
R4_11 17 20 26
C4_111 17 44 6.42888e-17
C4_112 20 44 6.42888e-17
R4_12 16 17 13
C4_121 16 44 5.3574e-17
C4_122 17 44 5.3574e-17
R4_13 19 20 26
C4_131 19 44 6.42888e-17
C4_132 20 44 6.42888e-17
R4_14 15 19 26
C4_141 15 44 6.42888e-17
C4_142 19 44 6.42888e-17
R4_15 13 15 13
C4_151 13 44 5.3574e-17
C4_152 15 44 5.3574e-17
R4_16 11 13 26
C4_161 11 44 6.42888e-17
C4_162 13 44 6.42888e-17
R4_17 18 20 26
C4_171 18 44 6.42888e-17
C4_172 20 44 6.42888e-17
R4_18 14 18 26
C4_181 14 44 6.42888e-17
C4_182 18 44 6.42888e-17
R4_19 12 14 13
C4_191 12 44 5.3574e-17
C4_192 14 44 5.3574e-17
R4_20 9 12 26
C4_201 9 44 6.42888e-17
C4_202 12 44 6.42888e-17
R3_1 24 23 15
R3_2 25 23 15
R3_3 32 31 15
R3_4 38 37 15
R3_5 41 37 15
R3_6 39 37 15
R3_7 32 35 480
C3_71 32 44 8.69778e-17
C3_72 35 44 8.69778e-17
R3_8 29 32 480
C3_81 29 44 8.0535e-17
C3_82 32 44 8.0535e-17
R3_9 32 34 480
C3_91 32 44 8.69778e-17
C3_92 34 44 8.69778e-17
R3_10 28 32 480
C3_101 28 44 8.0535e-17
C3_102 32 44 8.0535e-17
R3_11 32 33 480
C3_111 32 44 8.69778e-17
C3_112 33 44 8.69778e-17
R3_12 27 32 480
C3_121 27 44 8.0535e-17
C3_122 32 44 8.0535e-17
R3_13 32 36 480
C3_131 32 44 8.69778e-17
C3_132 36 44 8.69778e-17
R3_14 30 32 480
C3_141 30 44 8.0535e-17
C3_142 32 44 8.0535e-17
R3_15 39 41 13
C3_151 39 44 5.3574e-17
C3_152 41 44 5.3574e-17
R3_16 38 39 13
C3_161 38 44 5.3574e-17
C3_162 39 44 5.3574e-17
R3_17 38 40 26
C3_171 38 44 7.50036e-17
C3_172 40 44 7.50036e-17
R3_18 31 40 52
C3_181 31 44 1.28578e-16
C3_182 40 44 1.28578e-16
R3_19 26 31 52
C3_191 26 44 1.17863e-16
C3_192 31 44 1.17863e-16
R3_20 25 24 13
C3_201 25 44 5.3574e-17
C3_202 24 44 5.3574e-17
R3_21 24 26 26
C3_211 24 44 7.50036e-17
C3_212 26 44 7.50036e-17
R2_1 51 47 15
R2_2 48 47 15
R2_3 52 49 15
R2_4 50 49 15
R2_5 46 45 15
R2_6 44 46 26
C2_61 44 44 6.42888e-17
C2_62 46 44 6.42888e-17
R2_7 50 52 26
C2_71 50 44 7.50036e-17
C2_72 52 44 7.50036e-17
R2_8 44 50 26
C2_81 44 44 6.42888e-17
C2_82 50 44 6.42888e-17
R2_9 48 51 26
C2_91 48 44 7.50036e-17
C2_92 51 44 7.50036e-17
R2_10 44 48 26
C2_101 44 44 6.42888e-17
C2_102 48 44 6.42888e-17
R1_1 59 55 15
R1_2 56 55 15
R1_3 64 61 15
R1_4 66 61 15
R1_5 65 61 15
R1_6 62 61 15
R1_7 57 63 3.75
R1_8 57 58 7.5
R1_9 60 57 52
C1_91 60 44 1.28578e-16
C1_92 57 44 1.28578e-16
R1_10 65 66 26
C1_101 65 44 6.42888e-17
C1_102 66 44 6.42888e-17
R1_11 64 65 13
C1_111 64 44 5.3574e-17
C1_112 65 44 5.3574e-17
R1_12 62 64 26
C1_121 62 44 6.42888e-17
C1_122 64 44 6.42888e-17
R1_13 60 62 13
C1_131 60 44 5.3574e-17
C1_132 62 44 5.3574e-17
R1_14 59 60 39
C1_141 59 44 9.64332e-17
C1_142 60 44 9.64332e-17
R1_15 56 59 26
C1_151 56 44 7.50036e-17
C1_152 59 44 7.50036e-17
.ends buf_x8
