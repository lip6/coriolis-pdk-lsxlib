* Spice description of oa3ao322_x4
* Spice driver version 452094893
* Date ( dd/mm/yyyy hh:mm:ss ):  8/05/2026 at 14:23:17

* INTERF i0 i1 i2 i3 i4 i5 i6 q vdd vss

.subckt oa3ao322_x4 55 81 49 14 20 2 8 115 93 102
* NET 2 = i5
* NET 8 = i6
* NET 14 = i3
* NET 20 = i4
* NET 49 = i2
* NET 55 = i0
* NET 81 = i1
* NET 93 = vdd
* NET 102 = vss
* NET 115 = q
Mtr_00018 27 10 72 93 sky130_fd_pr__pfet_01v8__model L=0.15U W=1.5U AS=0.435P AD=0.435P PS=3.58U PD=3.58U
Mtr_00017 38 15 72 93 sky130_fd_pr__pfet_01v8__model L=0.15U W=2.46U AS=0.7134P AD=0.7134P PS=5.5U PD=5.5U
Mtr_00016 35 21 38 93 sky130_fd_pr__pfet_01v8__model L=0.15U W=2.46U AS=0.7134P AD=0.7134P PS=5.5U PD=5.5U
Mtr_00015 88 58 26 93 sky130_fd_pr__pfet_01v8__model L=0.15U W=1.5U AS=0.435P AD=0.435P PS=3.58U PD=3.58U
Mtr_00014 26 84 89 93 sky130_fd_pr__pfet_01v8__model L=0.15U W=1.5U AS=0.435P AD=0.435P PS=3.58U PD=3.58U
Mtr_00013 89 52 27 93 sky130_fd_pr__pfet_01v8__model L=0.15U W=1.5U AS=0.435P AD=0.435P PS=3.58U PD=3.58U
Mtr_00012 35 3 25 93 sky130_fd_pr__pfet_01v8__model L=0.15U W=2.46U AS=0.7134P AD=0.7134P PS=5.5U PD=5.5U
Mtr_00011 116 68 87 93 sky130_fd_pr__pfet_01v8__model L=0.15U W=2.46U AS=0.7134P AD=0.7134P PS=5.5U PD=5.5U
Mtr_00010 116 71 88 93 sky130_fd_pr__pfet_01v8__model L=0.15U W=2.46U AS=0.7134P AD=0.7134P PS=5.5U PD=5.5U
Mtr_00009 114 61 103 102 sky130_fd_pr__nfet_01v8__model L=0.15U W=1.26U AS=0.3654P AD=0.3654P PS=3.1U PD=3.1U
Mtr_00008 105 62 114 102 sky130_fd_pr__nfet_01v8__model L=0.15U W=1.26U AS=0.3654P AD=0.3654P PS=3.1U PD=3.1U
Mtr_00007 109 1 43 102 sky130_fd_pr__nfet_01v8__model L=0.15U W=0.54U AS=0.1566P AD=0.1566P PS=1.66U PD=1.66U
Mtr_00006 63 50 96 102 sky130_fd_pr__nfet_01v8__model L=0.15U W=1.14U AS=0.3306P AD=0.3306P PS=2.86U PD=2.86U
Mtr_00005 41 7 63 102 sky130_fd_pr__nfet_01v8__model L=0.15U W=0.54U AS=0.1566P AD=0.1566P PS=1.66U PD=1.66U
Mtr_00004 107 13 41 102 sky130_fd_pr__nfet_01v8__model L=0.15U W=0.54U AS=0.1566P AD=0.1566P PS=1.66U PD=1.66U
Mtr_00003 43 19 107 102 sky130_fd_pr__nfet_01v8__model L=0.15U W=0.54U AS=0.1566P AD=0.1566P PS=1.66U PD=1.66U
Mtr_00002 96 82 99 102 sky130_fd_pr__nfet_01v8__model L=0.15U W=1.14U AS=0.3306P AD=0.3306P PS=2.86U PD=2.86U
Mtr_00001 99 56 105 102 sky130_fd_pr__nfet_01v8__model L=0.15U W=1.14U AS=0.3306P AD=0.3306P PS=2.86U PD=2.86U
R17_1 4 2 15
R17_2 4 3 528
C17_21 4 102 9.34206e-17
C17_22 3 102 9.34206e-17
R17_3 1 4 528
C17_31 1 102 9.34206e-17
C17_32 4 102 9.34206e-17
R16_1 9 8 15
R16_2 9 10 672
C16_21 9 102 1.19192e-16
C16_22 10 102 1.19192e-16
R16_3 7 9 528
C16_31 7 102 9.10046e-17
C16_32 9 102 9.10046e-17
R15_1 16 14 15
R15_2 16 15 528
C15_21 16 102 9.34206e-17
C15_22 15 102 9.34206e-17
R15_3 13 16 528
C15_31 13 102 9.10046e-17
C15_32 16 102 9.10046e-17
R14_1 22 20 15
R14_2 22 21 528
C14_21 22 102 9.34206e-17
C14_22 21 102 9.34206e-17
R14_3 19 22 528
C14_31 19 102 9.10046e-17
C14_32 22 102 9.10046e-17
R13_1 32 25 15
R13_2 31 27 15
R13_3 30 26 15
R13_4 28 30 13
C13_41 28 102 5.3574e-17
C13_42 30 102 5.3574e-17
R13_5 28 29 52
C13_51 28 102 1.28578e-16
C13_52 29 102 1.28578e-16
R13_6 29 31 13
C13_61 29 102 5.3574e-17
C13_62 31 102 5.3574e-17
R13_7 31 32 104
C13_71 31 102 2.4644e-16
C13_72 32 102 2.4644e-16
R10_1 42 41 15
R10_2 44 43 7.5
R10_3 44 46 13
C10_31 44 102 5.3574e-17
C10_32 46 102 5.3574e-17
R10_4 45 46 52
C10_41 45 102 1.28578e-16
C10_42 46 102 1.28578e-16
R10_5 42 45 13
C10_51 42 102 5.3574e-17
C10_52 45 102 5.3574e-17
R9_1 51 49 15
R9_2 50 51 432
C9_21 50 102 7.73136e-17
C9_22 51 102 7.73136e-17
R9_3 51 52 672
C9_31 51 102 1.19192e-16
C9_32 52 102 1.19192e-16
R8_1 57 55 15
R8_2 57 58 672
C8_21 57 102 1.19192e-16
C8_22 58 102 1.19192e-16
R8_3 56 57 432
C8_31 56 102 7.73136e-17
C8_32 57 102 7.73136e-17
R7_1 69 70 15
R7_2 73 72 15
R7_3 78 72 15
R7_4 74 72 15
R7_5 64 63 15
R7_6 66 63 15
R7_7 66 65 13
C7_71 66 102 4.28592e-17
C7_72 65 102 4.28592e-17
R7_8 64 66 26
C7_81 64 102 6.42888e-17
C7_82 66 102 6.42888e-17
R7_9 65 67 26
C7_91 65 102 7.50036e-17
C7_92 67 102 7.50036e-17
R7_10 73 78 26
C7_101 73 102 5.89314e-17
C7_102 78 102 5.89314e-17
R7_11 74 73 26
C7_111 74 102 6.96462e-17
C7_112 73 102 6.96462e-17
R7_12 67 74 52
C7_121 67 102 1.17863e-16
C7_122 74 102 1.17863e-16
R7_13 77 73 104
C7_131 77 102 2.57155e-16
C7_132 73 102 2.57155e-16
R7_14 77 76 13
C7_141 77 102 5.3574e-17
C7_142 76 102 5.3574e-17
R7_15 75 76 52
C7_151 75 102 1.28578e-16
C7_152 76 102 1.28578e-16
R7_16 70 75 78
C7_161 70 102 1.92866e-16
C7_162 75 102 1.92866e-16
R7_17 69 68 528
C7_171 69 102 9.34206e-17
C7_172 68 102 9.34206e-17
R7_18 61 69 432
C7_181 61 102 7.40922e-17
C7_182 69 102 7.40922e-17
R7_19 69 71 528
C7_191 69 102 9.34206e-17
C7_192 71 102 9.34206e-17
R7_20 62 69 432
C7_201 62 102 7.40922e-17
C7_202 69 102 7.40922e-17
R6_1 83 81 15
R6_2 83 84 672
C6_21 83 102 1.19192e-16
C6_22 84 102 1.19192e-16
R6_3 82 83 432
C6_31 82 102 7.73136e-17
C6_32 83 102 7.73136e-17
R5_1 91 88 15
R5_2 92 89 15
R5_3 90 87 15
R5_4 90 93 26
C5_41 90 102 6.42888e-17
C5_42 93 102 6.42888e-17
R5_5 92 93 26
C5_51 92 102 6.42888e-17
C5_52 93 102 6.42888e-17
R5_6 91 93 26
C5_61 91 102 6.42888e-17
C5_62 93 102 6.42888e-17
R2_1 104 103 15
R2_2 111 103 15
R2_3 110 109 15
R2_4 108 107 15
R2_5 106 105 15
R2_6 102 106 26
C2_61 102 102 6.42888e-17
C2_62 106 102 6.42888e-17
R2_7 102 108 26
C2_71 102 102 6.42888e-17
C2_72 108 102 6.42888e-17
R2_8 102 110 26
C2_81 102 102 6.42888e-17
C2_82 110 102 6.42888e-17
R2_9 104 111 26
C2_91 104 102 6.42888e-17
C2_92 111 102 6.42888e-17
R2_10 102 104 26
C2_101 102 102 6.42888e-17
C2_102 104 102 6.42888e-17
R1_1 115 114 7.5
R1_2 115 116 7.5
.ends oa3ao322_x4
