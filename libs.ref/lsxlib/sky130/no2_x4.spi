* Spice description of no2_x4
* Spice driver version -442963027
* Date ( dd/mm/yyyy hh:mm:ss ):  8/05/2026 at 14:22:51

* INTERF i0 i1 nq vdd vss

.subckt no2_x4 1 6 57 36 61
* NET 1 = i0
* NET 6 = i1
* NET 36 = vdd
* NET 57 = nq
* NET 61 = vss
Mtr_00010 30 51 21 36 sky130_fd_pr__pfet_01v8__model L=0.15U W=1.26U AS=0.3654P AD=0.3654P PS=3.1U PD=3.1U
Mtr_00009 58 18 30 36 sky130_fd_pr__pfet_01v8__model L=0.15U W=2.46U AS=0.7134P AD=0.7134P PS=5.5U PD=5.5U
Mtr_00008 29 17 58 36 sky130_fd_pr__pfet_01v8__model L=0.15U W=2.46U AS=0.7134P AD=0.7134P PS=5.5U PD=5.5U
Mtr_00007 29 8 26 36 sky130_fd_pr__pfet_01v8__model L=0.15U W=2.46U AS=0.7134P AD=0.7134P PS=5.5U PD=5.5U
Mtr_00006 26 3 48 36 sky130_fd_pr__pfet_01v8__model L=0.15U W=2.46U AS=0.7134P AD=0.7134P PS=5.5U PD=5.5U
Mtr_00005 13 43 66 61 sky130_fd_pr__nfet_01v8__model L=0.15U W=0.66U AS=0.1914P AD=0.1914P PS=1.9U PD=1.9U
Mtr_00004 66 12 56 61 sky130_fd_pr__nfet_01v8__model L=0.15U W=1.26U AS=0.3654P AD=0.3654P PS=3.1U PD=3.1U
Mtr_00003 56 11 64 61 sky130_fd_pr__nfet_01v8__model L=0.15U W=1.26U AS=0.3654P AD=0.3654P PS=3.1U PD=3.1U
Mtr_00002 39 7 64 61 sky130_fd_pr__nfet_01v8__model L=0.15U W=0.66U AS=0.1914P AD=0.1914P PS=1.9U PD=1.9U
Mtr_00001 62 2 39 61 sky130_fd_pr__nfet_01v8__model L=0.15U W=0.66U AS=0.1914P AD=0.1914P PS=1.9U PD=1.9U
R8_1 3 1 15
R8_2 2 3 1008
C8_21 2 61 1.75566e-16
C8_22 3 61 1.75566e-16
R7_1 8 6 15
R7_2 7 8 1008
C7_21 7 61 1.75566e-16
C7_22 8 61 1.75566e-16
R6_1 20 19 15
R6_2 22 21 15
R6_3 23 21 15
R6_4 14 13 15
R6_5 16 15 15
R6_6 12 16 288
C6_61 12 61 5.15424e-17
C6_62 16 61 5.15424e-17
R6_7 11 12 192
C6_71 11 61 3.86568e-17
C6_72 12 61 3.86568e-17
R6_8 22 23 26
C6_81 22 61 7.50036e-17
C6_82 23 61 7.50036e-17
R6_9 19 22 52
C6_91 19 61 1.39292e-16
C6_92 22 61 1.39292e-16
R6_10 15 19 26
C6_101 15 61 8.57184e-17
C6_102 19 61 8.57184e-17
R6_11 14 15 39
C6_111 14 61 1.07148e-16
C6_112 15 61 1.07148e-16
R6_12 18 20 288
C6_121 18 61 5.15424e-17
C6_122 20 61 5.15424e-17
R6_13 17 18 192
C6_131 17 61 3.86568e-17
C6_132 18 61 3.86568e-17
R4_1 34 29 15
R4_2 35 30 15
R4_3 33 30 15
R4_4 32 30 15
R4_5 31 30 15
R4_6 35 36 26
C4_61 35 61 6.42888e-17
C4_62 36 61 6.42888e-17
R4_7 33 35 26
C4_71 33 61 6.42888e-17
C4_72 35 61 6.42888e-17
R4_8 32 33 26
C4_81 32 61 6.42888e-17
C4_82 33 61 6.42888e-17
R4_9 31 32 13
C4_91 31 61 5.3574e-17
C4_92 32 61 5.3574e-17
R4_10 34 36 26
C4_101 34 61 6.42888e-17
C4_102 36 61 6.42888e-17
R3_1 40 39 15
R3_2 46 45 15
R3_3 49 48 15
R3_4 53 48 15
R3_5 43 44 192
C3_51 43 61 3.86568e-17
C3_52 44 61 3.86568e-17
R3_6 51 52 192
C3_61 51 61 3.86568e-17
C3_62 52 61 3.86568e-17
R3_7 47 52 528
C3_71 47 61 9.01992e-17
C3_72 52 61 9.01992e-17
R3_8 44 47 336
C3_81 44 61 5.79852e-17
C3_82 47 61 5.79852e-17
R3_9 46 47 768
C3_91 46 61 1.28856e-16
C3_92 47 61 1.28856e-16
R3_10 49 53 13
C3_101 49 61 5.3574e-17
C3_102 53 61 5.3574e-17
R3_11 49 50 52
C3_111 49 61 1.39292e-16
C3_112 50 61 1.39292e-16
R3_12 45 50 78
C3_121 45 61 2.03581e-16
C3_122 50 61 2.03581e-16
R3_13 42 45 39
C3_131 42 61 9.64332e-17
C3_132 45 61 9.64332e-17
R3_14 41 42 26
C3_141 41 61 7.50036e-17
C3_142 42 61 7.50036e-17
R3_15 40 41 13
C3_151 40 61 5.3574e-17
C3_152 41 61 5.3574e-17
R2_1 57 56 7.5
R2_2 57 58 3.75
R1_1 68 66 15
R1_2 67 66 15
R1_3 63 62 15
R1_4 65 64 15
R1_5 61 65 26
C1_51 61 61 6.42888e-17
C1_52 65 61 6.42888e-17
R1_6 61 63 26
C1_61 61 61 6.42888e-17
C1_62 63 61 6.42888e-17
R1_7 67 68 26
C1_71 67 61 7.50036e-17
C1_72 68 61 7.50036e-17
R1_8 61 67 26
C1_81 61 61 6.42888e-17
C1_82 67 61 6.42888e-17
.ends no2_x4
