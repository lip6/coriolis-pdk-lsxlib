* Spice description of oa2ao222_x4
* Spice driver version 710462381
* Date ( dd/mm/yyyy hh:mm:ss ):  8/05/2026 at 14:22:51

* INTERF i0 i1 i2 i3 i4 q vdd vss

.subckt oa2ao222_x4 55 37 51 3 44 33 29 93
* NET 3 = i3
* NET 29 = vdd
* NET 33 = q
* NET 37 = i1
* NET 44 = i4
* NET 51 = i2
* NET 55 = i0
* NET 93 = vss
Mtr_00014 34 85 17 29 sky130_fd_pr__pfet_01v8__model L=0.15U W=2.46U AS=0.7134P AD=0.7134P PS=5.5U PD=5.5U
Mtr_00013 19 86 34 29 sky130_fd_pr__pfet_01v8__model L=0.15U W=2.46U AS=0.7134P AD=0.7134P PS=5.5U PD=5.5U
Mtr_00012 61 50 87 29 sky130_fd_pr__pfet_01v8__model L=0.15U W=2.46U AS=0.7134P AD=0.7134P PS=5.5U PD=5.5U
Mtr_00011 7 2 61 29 sky130_fd_pr__pfet_01v8__model L=0.15U W=2.46U AS=0.7134P AD=0.7134P PS=5.5U PD=5.5U
Mtr_00010 23 58 8 29 sky130_fd_pr__pfet_01v8__model L=0.15U W=1.26U AS=0.3654P AD=0.3654P PS=3.1U PD=3.1U
Mtr_00009 23 40 9 29 sky130_fd_pr__pfet_01v8__model L=0.15U W=1.26U AS=0.3654P AD=0.3654P PS=3.1U PD=3.1U
Mtr_00008 87 46 9 29 sky130_fd_pr__pfet_01v8__model L=0.15U W=1.26U AS=0.3654P AD=0.3654P PS=3.1U PD=3.1U
Mtr_00007 32 78 100 93 sky130_fd_pr__nfet_01v8__model L=0.15U W=1.26U AS=0.3654P AD=0.3654P PS=3.1U PD=3.1U
Mtr_00006 98 77 32 93 sky130_fd_pr__nfet_01v8__model L=0.15U W=1.26U AS=0.3654P AD=0.3654P PS=3.1U PD=3.1U
Mtr_00005 66 1 96 93 sky130_fd_pr__nfet_01v8__model L=0.15U W=0.66U AS=0.1914P AD=0.1914P PS=1.9U PD=1.9U
Mtr_00004 72 56 94 93 sky130_fd_pr__nfet_01v8__model L=0.15U W=0.66U AS=0.1914P AD=0.1914P PS=1.9U PD=1.9U
Mtr_00003 96 49 64 93 sky130_fd_pr__nfet_01v8__model L=0.15U W=0.66U AS=0.1914P AD=0.1914P PS=1.9U PD=1.9U
Mtr_00002 64 43 75 93 sky130_fd_pr__nfet_01v8__model L=0.15U W=0.66U AS=0.1914P AD=0.1914P PS=1.9U PD=1.9U
Mtr_00001 75 38 72 93 sky130_fd_pr__nfet_01v8__model L=0.15U W=0.66U AS=0.1914P AD=0.1914P PS=1.9U PD=1.9U
R13_1 4 3 15
R13_2 4 2 480
C13_21 4 93 8.69778e-17
C13_22 2 93 8.69778e-17
R13_3 1 4 576
C13_31 1 93 9.6642e-17
C13_32 4 93 9.6642e-17
R12_1 14 7 15
R12_2 13 9 15
R12_3 11 9 15
R12_4 10 8 15
R12_5 12 8 15
R12_6 10 12 13
C12_61 10 93 5.3574e-17
C12_62 12 93 5.3574e-17
R12_7 10 11 52
C12_71 10 93 1.28578e-16
C12_72 11 93 1.28578e-16
R12_8 11 13 13
C12_81 11 93 5.3574e-17
C12_82 13 93 5.3574e-17
R12_9 13 14 78
C12_91 13 93 1.82152e-16
C12_92 14 93 1.82152e-16
R11_1 21 17 15
R11_2 24 17 15
R11_3 27 17 15
R11_4 17 18 15
R11_5 25 19 15
R11_6 28 19 15
R11_7 22 19 15
R11_8 20 19 15
R11_9 26 23 15
R11_10 26 29 26
C11_101 26 93 6.42888e-17
C11_102 29 93 6.42888e-17
R11_11 28 29 26
C11_111 28 93 6.42888e-17
C11_112 29 93 6.42888e-17
R11_12 25 28 26
C11_121 25 93 6.42888e-17
C11_122 28 93 6.42888e-17
R11_13 22 25 26
C11_131 22 93 6.42888e-17
C11_132 25 93 6.42888e-17
R11_14 20 22 13
C11_141 20 93 5.3574e-17
C11_142 22 93 5.3574e-17
R11_15 27 29 26
C11_151 27 93 6.42888e-17
C11_152 29 93 6.42888e-17
R11_16 24 27 26
C11_161 24 93 6.42888e-17
C11_162 27 93 6.42888e-17
R11_17 21 24 26
C11_171 21 93 6.42888e-17
C11_172 24 93 6.42888e-17
R11_18 18 21 13
C11_181 18 93 5.3574e-17
C11_182 21 93 5.3574e-17
R10_1 33 32 7.5
R10_2 33 34 3.75
R9_1 39 37 15
R9_2 39 40 672
C9_21 39 93 1.16776e-16
C9_22 40 93 1.16776e-16
R9_3 38 39 576
C9_31 38 93 9.6642e-17
C9_32 39 93 9.6642e-17
R8_1 45 44 15
R8_2 45 46 672
C8_21 45 93 1.16776e-16
C8_22 46 93 1.16776e-16
R8_3 43 45 576
C8_31 43 93 9.6642e-17
C8_32 45 93 9.6642e-17
R7_1 52 51 15
R7_2 52 50 480
C7_21 52 93 8.69778e-17
C7_22 50 93 8.69778e-17
R7_3 49 52 528
C7_31 49 93 9.4226e-17
C7_32 52 93 9.4226e-17
R6_1 57 55 15
R6_2 57 58 672
C6_21 57 93 1.19192e-16
C6_22 58 93 1.19192e-16
R6_3 56 57 576
C6_31 56 93 9.6642e-17
C6_32 57 93 9.6642e-17
R4_1 65 64 15
R4_2 67 66 15
R4_3 67 69 13
C4_31 67 93 5.3574e-17
C4_32 69 93 5.3574e-17
R4_4 68 69 52
C4_41 68 93 1.28578e-16
C4_42 69 93 1.28578e-16
R4_5 65 68 13
C4_51 65 93 5.3574e-17
C4_52 68 93 5.3574e-17
R2_1 76 75 15
R2_2 82 81 15
R2_3 88 87 15
R2_4 90 87 15
R2_5 89 87 15
R2_6 83 85 672
C2_61 83 93 1.19192e-16
C2_62 85 93 1.19192e-16
R2_7 77 83 288
C2_71 77 93 4.8321e-17
C2_72 83 93 4.8321e-17
R2_8 84 86 672
C2_81 84 93 1.19192e-16
C2_82 86 93 1.19192e-16
R2_9 78 84 288
C2_91 78 93 4.8321e-17
C2_92 84 93 4.8321e-17
R2_10 83 84 192
C2_101 83 93 3.86568e-17
C2_102 84 93 3.86568e-17
R2_11 82 83 288
C2_111 82 93 5.15424e-17
C2_112 83 93 5.15424e-17
R2_12 88 90 26
C2_121 88 93 6.42888e-17
C2_122 90 93 6.42888e-17
R2_13 89 88 26
C2_131 89 93 6.42888e-17
C2_132 88 93 6.42888e-17
R2_14 80 89 52
C2_141 80 93 1.17863e-16
C2_142 89 93 1.17863e-16
R2_15 80 81 52
C2_151 80 93 1.39292e-16
C2_152 81 93 1.39292e-16
R2_16 79 80 13
C2_161 79 93 5.3574e-17
C2_162 80 93 5.3574e-17
R2_17 76 79 39
C2_171 76 93 1.07148e-16
C2_172 79 93 1.07148e-16
R1_1 96 97 15
R1_2 99 98 15
R1_3 102 98 15
R1_4 101 100 15
R1_5 103 100 15
R1_6 95 94 15
R1_7 93 95 26
C1_71 93 93 6.42888e-17
C1_72 95 93 6.42888e-17
R1_8 101 103 26
C1_81 101 93 7.50036e-17
C1_82 103 93 7.50036e-17
R1_9 93 101 26
C1_91 93 93 6.42888e-17
C1_92 101 93 6.42888e-17
R1_10 99 102 26
C1_101 99 93 7.50036e-17
C1_102 102 93 7.50036e-17
R1_11 93 99 26
C1_111 93 93 6.42888e-17
C1_112 99 93 6.42888e-17
R1_12 93 97 26
C1_121 93 93 6.42888e-17
C1_122 97 93 6.42888e-17
.ends oa2ao222_x4
