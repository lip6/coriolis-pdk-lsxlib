* Spice description of nmx3_x4
* Spice driver version -1981015123
* Date ( dd/mm/yyyy hh:mm:ss ):  8/05/2026 at 14:23:17

* INTERF cmd0 cmd1 i0 i1 i2 nq vdd vss

.subckt nmx3_x4 17 79 29 91 73 65 108 145
* NET 17 = cmd0
* NET 29 = i0
* NET 65 = nq
* NET 73 = i2
* NET 79 = cmd1
* NET 91 = i1
* NET 108 = vdd
* NET 145 = vss
Mtr_00024 99 141 44 108 sky130_fd_pr__pfet_01v8__model L=0.15U W=1.26U AS=0.3654P AD=0.3654P PS=3.1U PD=3.1U
Mtr_00023 98 40 66 108 sky130_fd_pr__pfet_01v8__model L=0.15U W=2.46U AS=0.7134P AD=0.7134P PS=5.5U PD=5.5U
Mtr_00022 66 41 99 108 sky130_fd_pr__pfet_01v8__model L=0.15U W=2.46U AS=0.7134P AD=0.7134P PS=5.5U PD=5.5U
Mtr_00021 98 23 58 108 sky130_fd_pr__pfet_01v8__model L=0.15U W=0.78U AS=0.2262P AD=0.2262P PS=2.14U PD=2.14U
Mtr_00020 161 81 97 108 sky130_fd_pr__pfet_01v8__model L=0.15U W=0.78U AS=0.2262P AD=0.2262P PS=2.14U PD=2.14U
Mtr_00019 138 31 1 108 sky130_fd_pr__pfet_01v8__model L=0.15U W=1.14U AS=0.3306P AD=0.3306P PS=2.86U PD=2.86U
Mtr_00018 13 75 7 108 sky130_fd_pr__pfet_01v8__model L=0.15U W=1.14U AS=0.3306P AD=0.3306P PS=2.86U PD=2.86U
Mtr_00017 135 87 13 108 sky130_fd_pr__pfet_01v8__model L=0.15U W=1.14U AS=0.3306P AD=0.3306P PS=2.86U PD=2.86U
Mtr_00016 4 164 135 108 sky130_fd_pr__pfet_01v8__model L=0.15U W=1.14U AS=0.3306P AD=0.3306P PS=2.86U PD=2.86U
Mtr_00015 1 24 102 108 sky130_fd_pr__pfet_01v8__model L=0.15U W=1.14U AS=0.3306P AD=0.3306P PS=2.86U PD=2.86U
Mtr_00014 102 60 8 108 sky130_fd_pr__pfet_01v8__model L=0.15U W=1.14U AS=0.3306P AD=0.3306P PS=2.86U PD=2.86U
Mtr_00013 8 94 4 108 sky130_fd_pr__pfet_01v8__model L=0.15U W=1.14U AS=0.3306P AD=0.3306P PS=2.86U PD=2.86U
Mtr_00012 36 130 152 145 sky130_fd_pr__nfet_01v8__model L=0.15U W=0.66U AS=0.1914P AD=0.1914P PS=1.9U PD=1.9U
Mtr_00011 152 35 64 145 sky130_fd_pr__nfet_01v8__model L=0.15U W=1.26U AS=0.3654P AD=0.3654P PS=3.1U PD=3.1U
Mtr_00010 64 34 150 145 sky130_fd_pr__nfet_01v8__model L=0.15U W=1.26U AS=0.3654P AD=0.3654P PS=3.1U PD=3.1U
Mtr_00009 126 28 69 145 sky130_fd_pr__nfet_01v8__model L=0.15U W=0.54U AS=0.1566P AD=0.1566P PS=1.66U PD=1.66U
Mtr_00008 148 16 113 145 sky130_fd_pr__nfet_01v8__model L=0.15U W=0.54U AS=0.1566P AD=0.1566P PS=1.66U PD=1.66U
Mtr_00007 69 50 148 145 sky130_fd_pr__nfet_01v8__model L=0.15U W=0.54U AS=0.1566P AD=0.1566P PS=1.66U PD=1.66U
Mtr_00006 53 21 150 145 sky130_fd_pr__nfet_01v8__model L=0.15U W=0.42U AS=0.1218P AD=0.1218P PS=1.42U PD=1.42U
Mtr_00005 146 78 157 145 sky130_fd_pr__nfet_01v8__model L=0.15U W=0.42U AS=0.1218P AD=0.1218P PS=1.42U PD=1.42U
Mtr_00004 120 72 111 145 sky130_fd_pr__nfet_01v8__model L=0.15U W=0.54U AS=0.1566P AD=0.1566P PS=1.66U PD=1.66U
Mtr_00003 117 80 123 145 sky130_fd_pr__nfet_01v8__model L=0.15U W=0.54U AS=0.1566P AD=0.1566P PS=1.66U PD=1.66U
Mtr_00002 123 159 120 145 sky130_fd_pr__nfet_01v8__model L=0.15U W=0.54U AS=0.1566P AD=0.1566P PS=1.66U PD=1.66U
Mtr_00001 113 92 117 145 sky130_fd_pr__nfet_01v8__model L=0.15U W=0.54U AS=0.1566P AD=0.1566P PS=1.66U PD=1.66U
R18_1 9 7 15
R18_2 10 8 15
R18_3 9 10 104
C18_31 9 145 2.4644e-16
C18_32 10 145 2.4644e-16
R16_1 22 17 15
R16_2 21 23 576
C16_21 21 145 1.0389e-16
C16_22 23 145 1.0389e-16
R16_3 22 23 528
C16_31 22 145 9.58367e-17
C16_32 23 145 9.58367e-17
R16_4 25 24 48
C16_41 25 145 1.28856e-17
C16_42 24 145 1.28856e-17
R16_5 22 25 384
C16_51 22 145 6.4428e-17
C16_52 25 145 6.4428e-17
R16_6 18 22 336
C16_61 18 145 5.79852e-17
C16_62 22 145 5.79852e-17
R16_7 16 19 48
C16_71 16 145 1.28856e-17
C16_72 19 145 1.28856e-17
R16_8 20 18 48
C16_81 20 145 1.28856e-17
C16_82 18 145 1.28856e-17
R16_9 19 20 192
C16_91 19 145 3.86568e-17
C16_92 20 145 3.86568e-17
R15_1 30 29 15
R15_2 31 29 15
R15_3 28 30 528
C15_31 28 145 9.34206e-17
C15_32 30 145 9.34206e-17
R14_1 39 38 15
R14_2 45 44 15
R14_3 46 44 15
R14_4 37 36 15
R14_5 43 42 15
R14_6 41 43 288
C14_61 41 145 5.15424e-17
C14_62 43 145 5.15424e-17
R14_7 40 41 192
C14_71 40 145 3.86568e-17
C14_72 41 145 3.86568e-17
R14_8 45 46 26
C14_81 45 145 7.50036e-17
C14_82 46 145 7.50036e-17
R14_9 42 45 52
C14_91 42 145 1.39292e-16
C14_92 45 145 1.39292e-16
R14_10 38 42 26
C14_101 38 145 8.57184e-17
C14_102 42 145 8.57184e-17
R14_11 37 38 39
C14_111 37 145 1.07148e-16
C14_112 38 145 1.07148e-16
R14_12 35 39 288
C14_121 35 145 5.15424e-17
C14_122 39 145 5.15424e-17
R14_13 34 35 192
C14_131 34 145 3.86568e-17
C14_132 35 145 3.86568e-17
R13_1 57 53 15
R13_2 59 58 15
R13_3 50 51 15
R13_4 55 54 15
R13_5 61 60 48
C13_51 61 145 1.28856e-17
C13_52 60 145 1.28856e-17
R13_6 55 61 720
C13_61 55 145 1.22413e-16
C13_62 61 145 1.22413e-16
R13_7 49 54 13
C13_71 49 145 5.3574e-17
C13_72 54 145 5.3574e-17
R13_8 51 52 13
C13_81 51 145 4.28592e-17
C13_82 52 145 4.28592e-17
R13_9 49 51 26
C13_91 49 145 8.57184e-17
C13_92 51 145 8.57184e-17
R13_10 52 56 13
C13_101 52 145 5.3574e-17
C13_102 56 145 5.3574e-17
R13_11 57 59 52
C13_111 57 145 1.39292e-16
C13_112 59 145 1.39292e-16
R13_12 56 57 26
C13_121 56 145 5.89314e-17
C13_122 57 145 5.89314e-17
R12_1 65 64 7.5
R12_2 65 66 3.75
R10_1 74 73 15
R10_2 74 75 768
C10_21 74 145 1.28856e-16
C10_22 75 145 1.28856e-16
R10_3 72 74 528
C10_31 72 145 9.34206e-17
C10_32 74 145 9.34206e-17
R9_1 82 79 15
R9_2 87 88 15
R9_3 80 86 384
C9_31 80 145 6.76494e-17
C9_32 86 145 6.76494e-17
R9_4 83 86 192
C9_41 83 145 3.2214e-17
C9_42 86 145 3.2214e-17
R9_5 83 84 288
C9_51 83 145 5.15424e-17
C9_52 84 145 5.15424e-17
R9_6 85 84 48
C9_61 85 145 1.28856e-17
C9_62 84 145 1.28856e-17
R9_7 85 87 528
C9_71 85 145 9.50313e-17
C9_72 87 145 9.50313e-17
R9_8 79 88 52
C9_81 79 145 1.28578e-16
C9_82 88 145 1.28578e-16
R9_9 82 81 288
C9_91 82 145 4.8321e-17
C9_92 81 145 4.8321e-17
R9_10 78 82 288
C9_101 78 145 5.15424e-17
C9_102 82 145 5.15424e-17
R8_1 93 91 15
R8_2 93 94 768
C8_21 93 145 1.28856e-16
C8_22 94 145 1.28856e-16
R8_3 92 93 528
C8_31 92 145 9.34206e-17
C8_32 93 145 9.34206e-17
R7_1 104 97 15
R7_2 101 99 15
R7_3 107 99 15
R7_4 103 99 15
R7_5 100 99 15
R7_6 106 98 15
R7_7 105 102 15
R7_8 105 108 26
C7_81 105 145 6.42888e-17
C7_82 108 145 6.42888e-17
R7_9 106 108 26
C7_91 106 145 6.42888e-17
C7_92 108 145 6.42888e-17
R7_10 107 108 26
C7_101 107 145 6.42888e-17
C7_102 108 145 6.42888e-17
R7_11 103 107 26
C7_111 103 145 6.42888e-17
C7_112 107 145 6.42888e-17
R7_12 101 103 26
C7_121 101 145 6.42888e-17
C7_122 103 145 6.42888e-17
R7_13 100 101 13
C7_131 100 145 5.3574e-17
C7_132 101 145 5.3574e-17
R7_14 104 108 26
C7_141 104 145 6.42888e-17
C7_142 108 145 6.42888e-17
R6_1 112 111 15
R6_2 114 113 15
R6_3 112 114 104
C6_31 112 145 2.4644e-16
C6_32 114 145 2.4644e-16
R3_1 124 123 15
R3_2 139 138 15
R3_3 136 135 15
R3_4 133 132 15
R3_5 127 126 15
R3_6 130 131 192
C3_61 130 145 3.86568e-17
C3_62 131 145 3.86568e-17
R3_7 141 142 192
C3_71 141 145 3.86568e-17
C3_72 142 145 3.86568e-17
R3_8 134 142 528
C3_81 134 145 9.01992e-17
C3_82 142 145 9.01992e-17
R3_9 131 134 336
C3_91 131 145 5.79852e-17
C3_92 134 145 5.79852e-17
R3_10 127 129 13
C3_101 127 145 5.3574e-17
C3_102 129 145 5.3574e-17
R3_11 133 134 768
C3_111 133 145 1.28856e-16
C3_112 134 145 1.28856e-16
R3_12 129 128 26
C3_121 129 145 7.50036e-17
C3_122 128 145 7.50036e-17
R3_13 132 140 78
C3_131 132 145 2.03581e-16
C3_132 140 145 2.03581e-16
R3_14 128 132 39
C3_141 128 145 9.64332e-17
C3_142 132 145 9.64332e-17
R3_15 139 140 26
C3_151 139 145 8.57184e-17
C3_152 140 145 8.57184e-17
R3_16 137 139 91
C3_161 137 145 2.25011e-16
C3_162 139 145 2.25011e-16
R3_17 136 137 26
C3_171 136 145 7.50036e-17
C3_172 137 145 7.50036e-17
R3_18 125 137 130
C3_181 125 145 3.00014e-16
C3_182 137 145 3.00014e-16
R3_19 124 125 26
C3_191 124 145 7.50036e-17
C3_192 125 145 7.50036e-17
R2_1 147 146 15
R2_2 154 152 15
R2_3 153 152 15
R2_4 149 148 15
R2_5 151 150 15
R2_6 145 151 26
C2_61 145 145 6.42888e-17
C2_62 151 145 6.42888e-17
R2_7 145 149 26
C2_71 145 145 6.42888e-17
C2_72 149 145 6.42888e-17
R2_8 153 154 26
C2_81 153 145 7.50036e-17
C2_82 154 145 7.50036e-17
R2_9 145 153 26
C2_91 145 145 6.42888e-17
C2_92 153 145 6.42888e-17
R2_10 145 147 26
C2_101 145 145 6.42888e-17
C2_102 147 145 6.42888e-17
R1_1 158 157 15
R1_2 159 160 15
R1_3 162 161 15
R1_4 164 165 15
R1_5 163 165 13
C1_51 163 145 5.3574e-17
C1_52 165 145 5.3574e-17
R1_6 162 163 65
C1_61 162 145 1.50007e-16
C1_62 163 145 1.50007e-16
R1_7 158 162 65
C1_71 158 145 1.71437e-16
C1_72 162 145 1.71437e-16
R1_8 158 160 26
C1_81 158 145 7.50036e-17
C1_82 160 145 7.50036e-17
.ends nmx3_x4
