* Spice description of ts_x8
* Spice driver version 805202861
* Date ( dd/mm/yyyy hh:mm:ss ):  8/05/2026 at 14:22:51

* INTERF cmd i q vdd vss

.subckt ts_x8 24 2 110 93 96
* NET 2 = i
* NET 24 = cmd
* NET 93 = vdd
* NET 96 = vss
* NET 110 = q
Mtr_00016 81 43 115 93 sky130_fd_pr__pfet_01v8__model L=0.15U W=2.46U AS=0.7134P AD=0.7134P PS=5.5U PD=5.5U
Mtr_00015 116 45 81 93 sky130_fd_pr__pfet_01v8__model L=0.15U W=2.46U AS=0.7134P AD=0.7134P PS=5.5U PD=5.5U
Mtr_00014 115 42 79 93 sky130_fd_pr__pfet_01v8__model L=0.15U W=2.46U AS=0.7134P AD=0.7134P PS=5.5U PD=5.5U
Mtr_00013 50 20 74 93 sky130_fd_pr__pfet_01v8__model L=0.15U W=1.38U AS=0.4002P AD=0.4002P PS=3.34U PD=3.34U
Mtr_00012 83 44 116 93 sky130_fd_pr__pfet_01v8__model L=0.15U W=2.46U AS=0.7134P AD=0.7134P PS=5.5U PD=5.5U
Mtr_00011 15 36 83 93 sky130_fd_pr__pfet_01v8__model L=0.15U W=1.26U AS=0.3654P AD=0.3654P PS=3.1U PD=3.1U
Mtr_00010 86 37 50 93 sky130_fd_pr__pfet_01v8__model L=0.15U W=1.38U AS=0.4002P AD=0.4002P PS=3.34U PD=3.34U
Mtr_00009 52 5 86 93 sky130_fd_pr__pfet_01v8__model L=0.15U W=1.38U AS=0.4002P AD=0.4002P PS=3.34U PD=3.34U
Mtr_00008 109 58 97 96 sky130_fd_pr__nfet_01v8__model L=0.15U W=1.26U AS=0.3654P AD=0.3654P PS=3.1U PD=3.1U
Mtr_00007 111 60 99 96 sky130_fd_pr__nfet_01v8__model L=0.15U W=1.26U AS=0.3654P AD=0.3654P PS=3.1U PD=3.1U
Mtr_00006 101 61 111 96 sky130_fd_pr__nfet_01v8__model L=0.15U W=1.26U AS=0.3654P AD=0.3654P PS=3.1U PD=3.1U
Mtr_00005 8 25 101 96 sky130_fd_pr__nfet_01v8__model L=0.15U W=0.66U AS=0.1914P AD=0.1914P PS=1.9U PD=1.9U
Mtr_00004 103 13 62 96 sky130_fd_pr__nfet_01v8__model L=0.15U W=0.78U AS=0.2262P AD=0.2262P PS=2.14U PD=2.14U
Mtr_00003 40 28 65 96 sky130_fd_pr__nfet_01v8__model L=0.15U W=0.78U AS=0.2262P AD=0.2262P PS=2.14U PD=2.14U
Mtr_00002 65 1 103 96 sky130_fd_pr__nfet_01v8__model L=0.15U W=0.78U AS=0.2262P AD=0.2262P PS=2.14U PD=2.14U
Mtr_00001 99 59 109 96 sky130_fd_pr__nfet_01v8__model L=0.15U W=1.26U AS=0.3654P AD=0.3654P PS=3.1U PD=3.1U
R8_1 3 2 15
R8_2 4 2 15
R8_3 4 5 384
C8_31 4 96 7.08708e-17
C8_32 5 96 7.08708e-17
R8_4 1 3 288
C8_41 1 96 5.47638e-17
C8_42 3 96 5.47638e-17
R7_1 9 8 15
R7_2 18 17 15
R7_3 12 11 15
R7_4 16 15 15
R7_5 21 15 15
R7_6 13 14 192
C7_61 13 96 3.54354e-17
C7_62 14 96 3.54354e-17
R7_7 12 14 288
C7_71 12 96 5.15424e-17
C7_72 14 96 5.15424e-17
R7_8 16 21 26
C7_81 16 96 7.50036e-17
C7_82 21 96 7.50036e-17
R7_9 18 20 288
C7_91 18 96 5.15424e-17
C7_92 20 96 5.15424e-17
R7_10 16 19 13
C7_101 16 96 3.21444e-17
C7_102 19 96 3.21444e-17
R7_11 17 19 13
C7_111 17 96 4.28592e-17
C7_112 19 96 4.28592e-17
R7_12 11 17 91
C7_121 11 96 2.14296e-16
C7_122 17 96 2.14296e-16
R7_13 10 11 26
C7_131 10 96 7.50036e-17
C7_132 11 96 7.50036e-17
R7_14 9 10 13
C7_141 9 96 3.21444e-17
C7_142 10 96 3.21444e-17
R6_1 27 26 15
R6_2 33 32 15
R6_3 35 34 15
R6_4 30 29 15
R6_5 28 31 480
C6_51 28 96 8.0535e-17
C6_52 31 96 8.0535e-17
R6_6 30 31 384
C6_61 30 96 6.4428e-17
C6_62 31 96 6.4428e-17
R6_7 29 34 39
C6_71 29 96 1.07148e-16
C6_72 34 96 1.07148e-16
R6_8 35 37 384
C6_81 35 96 7.08708e-17
C6_82 37 96 7.08708e-17
R6_9 33 35 624
C6_91 33 96 1.07917e-16
C6_92 35 96 1.07917e-16
R6_10 33 36 432
C6_101 33 96 7.40922e-17
C6_102 36 96 7.40922e-17
R6_11 24 32 13
C6_111 24 96 4.28592e-17
C6_112 32 96 4.28592e-17
R6_12 25 27 192
C6_121 25 96 3.86568e-17
C6_122 27 96 3.86568e-17
R6_13 24 26 13
C6_131 24 96 4.28592e-17
C6_132 26 96 4.28592e-17
R5_1 49 48 15
R5_2 53 52 15
R5_3 55 52 15
R5_4 41 40 15
R5_5 51 50 15
R5_6 54 50 15
R5_7 51 54 26
C5_71 51 96 6.42888e-17
C5_72 54 96 6.42888e-17
R5_8 51 53 52
C5_81 51 96 1.28578e-16
C5_82 53 96 1.28578e-16
R5_9 53 55 26
C5_91 53 96 6.42888e-17
C5_92 55 96 6.42888e-17
R5_10 48 53 65
C5_101 48 96 1.50007e-16
C5_102 53 96 1.50007e-16
R5_11 41 48 78
C5_111 41 96 1.92866e-16
C5_112 48 96 1.92866e-16
R5_12 46 49 336
C5_121 46 96 1.15096e-16
C5_122 49 96 1.15096e-16
R5_13 47 46 0.001
C5_131 47 96 1.53128e-17
C5_132 46 96 1.53128e-17
R5_14 44 47 288
C5_141 44 96 1.01848e-16
C5_142 47 96 1.01848e-16
R5_15 45 44 96
C5_151 45 96 3.97454e-17
C5_152 44 96 3.97454e-17
R5_16 43 45 96
C5_161 43 96 3.97454e-17
C5_162 45 96 3.97454e-17
R5_17 42 43 96
C5_171 42 96 3.97454e-17
C5_172 43 96 3.97454e-17
R4_1 73 72 15
R4_2 76 74 15
R4_3 75 74 15
R4_4 63 62 15
R4_5 67 65 15
R4_6 67 66 13
C4_61 67 96 5.3574e-17
C4_62 66 96 5.3574e-17
R4_7 64 66 52
C4_71 64 96 1.28578e-16
C4_72 66 96 1.28578e-16
R4_8 75 76 26
C4_81 75 96 7.50036e-17
C4_82 76 96 7.50036e-17
R4_9 72 75 78
C4_91 72 96 2.03581e-16
C4_92 75 96 2.03581e-16
R4_10 64 72 26
C4_101 64 96 7.50036e-17
C4_102 72 96 7.50036e-17
R4_11 63 64 13
C4_111 63 96 5.3574e-17
C4_112 64 96 5.3574e-17
R4_12 59 68 288
C4_121 59 96 5.47638e-17
C4_122 68 96 5.47638e-17
R4_13 58 69 288
C4_131 58 96 5.47638e-17
C4_132 69 96 5.47638e-17
R4_14 61 70 288
C4_141 61 96 5.47638e-17
C4_142 70 96 5.47638e-17
R4_15 70 73 336
C4_151 70 96 1.12612e-16
C4_152 73 96 1.12612e-16
R4_16 71 70 96
C4_161 71 96 3.97454e-17
C4_162 70 96 3.97454e-17
R4_17 68 71 96
C4_171 68 96 3.97454e-17
C4_172 71 96 3.97454e-17
R4_18 69 68 96
C4_181 69 96 3.97454e-17
C4_182 68 96 3.97454e-17
R4_19 60 71 288
C4_191 60 96 5.47638e-17
C4_192 71 96 5.47638e-17
R3_1 89 79 15
R3_2 84 79 15
R3_3 87 79 15
R3_4 80 79 15
R3_5 92 86 15
R3_6 91 83 15
R3_7 82 81 15
R3_8 88 81 15
R3_9 85 81 15
R3_10 90 81 15
R3_11 90 93 26
C3_111 90 96 6.42888e-17
C3_112 93 96 6.42888e-17
R3_12 88 90 26
C3_121 88 96 6.42888e-17
C3_122 90 96 6.42888e-17
R3_13 85 88 13
C3_131 85 96 5.3574e-17
C3_132 88 96 5.3574e-17
R3_14 82 85 13
C3_141 82 96 5.3574e-17
C3_142 85 96 5.3574e-17
R3_15 91 93 26
C3_151 91 96 6.42888e-17
C3_152 93 96 6.42888e-17
R3_16 92 93 26
C3_161 92 96 6.42888e-17
C3_162 93 96 6.42888e-17
R3_17 89 93 26
C3_171 89 96 6.42888e-17
C3_172 93 96 6.42888e-17
R3_18 87 89 26
C3_181 87 96 6.42888e-17
C3_182 89 96 6.42888e-17
R3_19 84 87 13
C3_191 84 96 5.3574e-17
C3_192 87 96 5.3574e-17
R3_20 80 84 13
C3_201 80 96 5.3574e-17
C3_202 84 96 5.3574e-17
R2_1 105 97 15
R2_2 98 97 15
R2_3 102 101 15
R2_4 104 103 15
R2_5 106 99 15
R2_6 100 99 15
R2_7 100 106 26
C2_71 100 96 6.42888e-17
C2_72 106 96 6.42888e-17
R2_8 96 100 26
C2_81 96 96 6.42888e-17
C2_82 100 96 6.42888e-17
R2_9 96 104 26
C2_91 96 96 6.42888e-17
C2_92 104 96 6.42888e-17
R2_10 96 102 26
C2_101 96 96 6.42888e-17
C2_102 102 96 6.42888e-17
R2_11 98 105 26
C2_111 98 96 6.42888e-17
C2_112 105 96 6.42888e-17
R2_12 96 98 26
C2_121 96 96 6.42888e-17
C2_122 98 96 6.42888e-17
R1_1 110 109 7.5
R1_2 110 115 3.75
R1_3 118 116 15
R1_4 120 116 15
R1_5 119 116 15
R1_6 117 116 15
R1_7 112 111 15
R1_8 113 111 15
R1_9 119 120 26
C1_91 119 96 6.42888e-17
C1_92 120 96 6.42888e-17
R1_10 118 119 13
C1_101 118 96 5.3574e-17
C1_102 119 96 5.3574e-17
R1_11 117 118 13
C1_111 117 96 5.3574e-17
C1_112 118 96 5.3574e-17
R1_12 114 117 26
C1_121 114 96 7.50036e-17
C1_122 117 96 7.50036e-17
R1_13 113 114 39
C1_131 113 96 9.64332e-17
C1_132 114 96 9.64332e-17
R1_14 112 113 26
C1_141 112 96 6.42888e-17
C1_142 113 96 6.42888e-17
R1_15 110 114 52
C1_151 110 96 1.28578e-16
C1_152 114 96 1.28578e-16
.ends ts_x8
