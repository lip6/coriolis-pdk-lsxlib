* Spice description of sff2_x4
* Spice driver version -1675990099
* Date ( dd/mm/yyyy hh:mm:ss ):  8/05/2026 at 14:22:51

* INTERF ck cmd i0 i1 q vdd vss

.subckt sff2_x4 110 173 180 116 42 37 206
* NET 37 = vdd
* NET 42 = q
* NET 54 = sff_m
* NET 77 = sff_s
* NET 93 = y
* NET 110 = ck
* NET 116 = i1
* NET 148 = ckr
* NET 173 = cmd
* NET 180 = i0
* NET 190 = u
* NET 206 = vss
Mtr_00034 200 236 10 37 sky130_fd_pr__pfet_01v8__model L=0.15U W=1.02U AS=0.2958P AD=0.2958P PS=2.62U PD=2.62U
Mtr_00033 10 118 24 37 sky130_fd_pr__pfet_01v8__model L=0.15U W=1.02U AS=0.2958P AD=0.2958P PS=2.62U PD=2.62U
Mtr_00032 23 184 13 37 sky130_fd_pr__pfet_01v8__model L=0.15U W=1.02U AS=0.2958P AD=0.2958P PS=2.62U PD=2.62U
Mtr_00031 233 176 23 37 sky130_fd_pr__pfet_01v8__model L=0.15U W=1.02U AS=0.2958P AD=0.2958P PS=2.62U PD=2.62U
Mtr_00030 13 177 200 37 sky130_fd_pr__pfet_01v8__model L=0.15U W=1.02U AS=0.2958P AD=0.2958P PS=2.62U PD=2.62U
Mtr_00029 16 85 47 37 sky130_fd_pr__pfet_01v8__model L=0.15U W=2.46U AS=0.7134P AD=0.7134P PS=5.5U PD=5.5U
Mtr_00028 25 202 4 37 sky130_fd_pr__pfet_01v8__model L=0.15U W=1.02U AS=0.2958P AD=0.2958P PS=2.62U PD=2.62U
Mtr_00027 65 142 7 37 sky130_fd_pr__pfet_01v8__model L=0.15U W=1.02U AS=0.2958P AD=0.2958P PS=2.62U PD=2.62U
Mtr_00026 7 101 27 37 sky130_fd_pr__pfet_01v8__model L=0.15U W=1.02U AS=0.2958P AD=0.2958P PS=2.62U PD=2.62U
Mtr_00025 4 162 65 37 sky130_fd_pr__pfet_01v8__model L=0.15U W=1.02U AS=0.2958P AD=0.2958P PS=2.62U PD=2.62U
Mtr_00024 47 86 17 37 sky130_fd_pr__pfet_01v8__model L=0.15U W=2.46U AS=0.7134P AD=0.7134P PS=5.5U PD=5.5U
Mtr_00023 103 143 87 37 sky130_fd_pr__pfet_01v8__model L=0.15U W=1.02U AS=0.2958P AD=0.2958P PS=2.62U PD=2.62U
Mtr_00022 87 164 1 37 sky130_fd_pr__pfet_01v8__model L=0.15U W=1.26U AS=0.3654P AD=0.3654P PS=3.1U PD=3.1U
Mtr_00021 103 67 27 37 sky130_fd_pr__pfet_01v8__model L=0.15U W=1.02U AS=0.2958P AD=0.2958P PS=2.62U PD=2.62U
Mtr_00020 139 111 21 37 sky130_fd_pr__pfet_01v8__model L=0.15U W=1.26U AS=0.3654P AD=0.3654P PS=3.1U PD=3.1U
Mtr_00019 21 141 167 37 sky130_fd_pr__pfet_01v8__model L=0.15U W=1.26U AS=0.3654P AD=0.3654P PS=3.1U PD=3.1U
Mtr_00018 1 48 16 37 sky130_fd_pr__pfet_01v8__model L=0.15U W=1.26U AS=0.3654P AD=0.3654P PS=3.1U PD=3.1U
Mtr_00017 187 174 190 206 sky130_fd_pr__nfet_01v8__model L=0.15U W=0.54U AS=0.1566P AD=0.1566P PS=1.66U PD=1.66U
Mtr_00016 208 114 187 206 sky130_fd_pr__nfet_01v8__model L=0.15U W=0.54U AS=0.1566P AD=0.1566P PS=1.66U PD=1.66U
Mtr_00015 190 231 225 206 sky130_fd_pr__nfet_01v8__model L=0.15U W=0.54U AS=0.1566P AD=0.1566P PS=1.66U PD=1.66U
Mtr_00014 225 182 207 206 sky130_fd_pr__nfet_01v8__model L=0.15U W=0.54U AS=0.1566P AD=0.1566P PS=1.66U PD=1.66U
Mtr_00013 207 172 228 206 sky130_fd_pr__nfet_01v8__model L=0.15U W=0.54U AS=0.1566P AD=0.1566P PS=1.66U PD=1.66U
Mtr_00012 74 193 210 206 sky130_fd_pr__nfet_01v8__model L=0.15U W=0.54U AS=0.1566P AD=0.1566P PS=1.66U PD=1.66U
Mtr_00011 51 127 77 206 sky130_fd_pr__nfet_01v8__model L=0.15U W=0.66U AS=0.1914P AD=0.1914P PS=1.9U PD=1.9U
Mtr_00010 41 80 212 206 sky130_fd_pr__nfet_01v8__model L=0.15U W=1.26U AS=0.3654P AD=0.3654P PS=3.1U PD=3.1U
Mtr_00009 213 81 41 206 sky130_fd_pr__nfet_01v8__model L=0.15U W=1.26U AS=0.3654P AD=0.3654P PS=3.1U PD=3.1U
Mtr_00008 209 109 122 206 sky130_fd_pr__nfet_01v8__model L=0.15U W=0.66U AS=0.1914P AD=0.1914P PS=1.9U PD=1.9U
Mtr_00007 148 124 209 206 sky130_fd_pr__nfet_01v8__model L=0.15U W=0.66U AS=0.1914P AD=0.1914P PS=1.9U PD=1.9U
Mtr_00006 212 40 51 206 sky130_fd_pr__nfet_01v8__model L=0.15U W=0.66U AS=0.1914P AD=0.1914P PS=1.9U PD=1.9U
Mtr_00005 77 151 96 206 sky130_fd_pr__nfet_01v8__model L=0.15U W=0.54U AS=0.1566P AD=0.1566P PS=1.66U PD=1.66U
Mtr_00004 96 56 211 206 sky130_fd_pr__nfet_01v8__model L=0.15U W=0.54U AS=0.1566P AD=0.1566P PS=1.66U PD=1.66U
Mtr_00003 211 93 71 206 sky130_fd_pr__nfet_01v8__model L=0.15U W=0.54U AS=0.1566P AD=0.1566P PS=1.66U PD=1.66U
Mtr_00002 71 150 54 206 sky130_fd_pr__nfet_01v8__model L=0.15U W=0.54U AS=0.1566P AD=0.1566P PS=1.66U PD=1.66U
Mtr_00001 54 125 74 206 sky130_fd_pr__nfet_01v8__model L=0.15U W=0.54U AS=0.1566P AD=0.1566P PS=1.66U PD=1.66U
R19_1 19 16 15
R19_2 22 16 15
R19_3 35 16 15
R19_4 18 17 15
R19_5 36 17 15
R19_6 29 17 15
R19_7 20 17 15
R19_8 28 27 15
R19_9 34 27 15
R19_10 32 21 15
R19_11 31 24 15
R19_12 33 25 15
R19_13 26 25 15
R19_14 30 23 15
R19_15 30 37 26
C19_151 30 206 6.42888e-17
C19_152 37 206 6.42888e-17
R19_16 33 37 26
C19_161 33 206 6.42888e-17
C19_162 37 206 6.42888e-17
R19_17 26 33 13
C19_171 26 206 4.28592e-17
C19_172 33 206 4.28592e-17
R19_18 31 37 26
C19_181 31 206 6.42888e-17
C19_182 37 206 6.42888e-17
R19_19 32 37 26
C19_191 32 206 6.42888e-17
C19_192 37 206 6.42888e-17
R19_20 34 37 26
C19_201 34 206 6.42888e-17
C19_202 37 206 6.42888e-17
R19_21 28 34 13
C19_211 28 206 4.28592e-17
C19_212 34 206 4.28592e-17
R19_22 36 37 26
C19_221 36 206 7.50036e-17
C19_222 37 206 7.50036e-17
R19_23 29 36 13
C19_231 29 206 5.3574e-17
C19_232 36 206 5.3574e-17
R19_24 20 29 13
C19_241 20 206 5.3574e-17
C19_242 29 206 5.3574e-17
R19_25 18 20 13
C19_251 18 206 5.3574e-17
C19_252 20 206 5.3574e-17
R19_26 35 37 26
C19_261 35 206 7.50036e-17
C19_262 37 206 7.50036e-17
R19_27 22 35 26
C19_271 22 206 6.42888e-17
C19_272 35 206 6.42888e-17
R19_28 19 22 26
C19_281 19 206 7.50036e-17
C19_282 22 206 7.50036e-17
R18_1 42 41 7.5
R18_2 42 47 3.75
R18_3 46 45 15
R18_4 44 43 15
R18_5 40 44 288
C18_51 40 206 5.15424e-17
C18_52 44 206 5.15424e-17
R18_6 46 48 576
C18_61 46 206 9.98634e-17
C18_62 48 206 9.98634e-17
R18_7 43 42 52
C18_71 43 206 1.17863e-16
C18_72 42 206 1.17863e-16
R18_8 45 42 52
C18_81 45 206 1.17863e-16
C18_82 42 206 1.17863e-16
R16_1 55 54 15
R16_2 59 58 15
R16_3 63 62 15
R16_4 66 65 15
R16_5 68 65 15
R16_6 66 68 13
C16_61 66 206 4.28592e-17
C16_62 68 206 4.28592e-17
R16_7 64 67 432
C16_71 64 206 7.40922e-17
C16_72 67 206 7.40922e-17
R16_8 61 66 39
C16_81 61 206 1.07148e-16
C16_82 66 206 1.07148e-16
R16_9 63 64 192
C16_91 63 206 3.86568e-17
C16_92 64 206 3.86568e-17
R16_10 56 60 336
C16_101 56 206 6.12066e-17
C16_102 60 206 6.12066e-17
R16_11 61 62 26
C16_111 61 206 6.42888e-17
C16_112 62 206 6.42888e-17
R16_12 59 60 192
C16_121 59 206 3.86568e-17
C16_122 60 206 3.86568e-17
R16_13 58 62 65
C16_131 58 206 1.50007e-16
C16_132 62 206 1.50007e-16
R16_14 57 58 26
C16_141 57 206 6.42888e-17
C16_142 58 206 6.42888e-17
R16_15 55 57 39
C16_151 55 206 1.07148e-16
C16_152 57 206 1.07148e-16
R13_1 78 77 15
R13_2 89 87 15
R13_3 84 83 15
R13_4 90 87 15
R13_5 84 86 576
C13_51 84 206 9.98634e-17
C13_52 86 206 9.98634e-17
R13_6 81 84 384
C13_61 81 206 6.76494e-17
C13_62 84 206 6.76494e-17
R13_7 84 85 576
C13_71 84 206 9.98634e-17
C13_72 85 206 9.98634e-17
R13_8 80 84 384
C13_81 80 206 6.76494e-17
C13_82 84 206 6.76494e-17
R13_9 89 90 13
C13_91 89 206 4.28592e-17
C13_92 90 206 4.28592e-17
R13_10 82 83 52
C13_101 82 206 1.17863e-16
C13_102 83 206 1.17863e-16
R13_11 89 88 13
C13_111 89 206 4.28592e-17
C13_112 88 206 4.28592e-17
R13_12 82 88 91
C13_121 82 206 2.14296e-16
C13_122 88 206 2.14296e-16
R13_13 79 82 65
C13_131 79 206 1.50007e-16
C13_132 82 206 1.50007e-16
R13_14 78 79 13
C13_141 78 206 4.28592e-17
C13_142 79 206 4.28592e-17
R12_1 97 96 15
R12_2 93 94 15
R12_3 104 103 15
R12_4 106 103 15
R12_5 101 102 15
R12_6 102 105 39
C12_61 102 206 9.64332e-17
C12_62 105 206 9.64332e-17
R12_7 104 106 13
C12_71 104 206 4.28592e-17
C12_72 106 206 4.28592e-17
R12_8 105 104 13
C12_81 105 206 5.3574e-17
C12_82 104 206 5.3574e-17
R12_9 100 105 52
C12_91 100 206 1.17863e-16
C12_92 105 206 1.17863e-16
R12_10 99 100 13
C12_101 99 206 4.28592e-17
C12_102 100 206 4.28592e-17
R12_11 95 99 52
C12_111 95 206 1.39292e-16
C12_112 99 206 1.39292e-16
R12_12 95 98 13
C12_121 95 206 4.28592e-17
C12_122 98 206 4.28592e-17
R12_13 94 95 13
C12_131 94 206 5.3574e-17
C12_132 95 206 5.3574e-17
R12_14 97 98 13
C12_141 97 206 5.3574e-17
C12_142 98 206 5.3574e-17
R11_1 109 110 15
R11_2 111 110 15
R10_1 117 116 15
R10_2 119 116 15
R10_3 118 119 48
C10_31 118 206 2.01449e-17
C10_32 119 206 2.01449e-17
R10_4 115 117 48
C10_41 115 206 2.01449e-17
C10_42 117 206 2.01449e-17
R10_5 114 115 288
C10_51 114 206 5.47638e-17
C10_52 115 206 5.47638e-17
R9_1 123 122 15
R9_2 140 139 15
R9_3 145 139 15
R9_4 132 131 15
R9_5 129 128 15
R9_6 134 135 15
R9_7 125 126 15
R9_8 126 135 39
C9_81 126 206 9.64332e-17
C9_82 135 206 9.64332e-17
R9_9 144 143 48
C9_91 144 206 1.28856e-17
C9_92 143 206 1.28856e-17
R9_10 124 130 336
C9_101 124 206 5.79852e-17
C9_102 130 206 5.79852e-17
R9_11 133 141 576
C9_111 133 206 9.98634e-17
C9_112 141 206 9.98634e-17
R9_12 136 142 624
C9_121 136 206 1.06306e-16
C9_122 142 206 1.06306e-16
R9_13 137 144 384
C9_131 137 206 7.08708e-17
C9_132 144 206 7.08708e-17
R9_14 127 138 672
C9_141 127 206 1.1597e-16
C9_142 138 206 1.1597e-16
R9_15 129 130 336
C9_151 129 206 5.79852e-17
C9_152 130 206 5.79852e-17
R9_16 137 138 288
C9_161 137 206 5.15424e-17
C9_162 138 206 5.15424e-17
R9_17 136 137 576
C9_171 136 206 9.6642e-17
C9_172 137 206 9.6642e-17
R9_18 134 136 192
C9_181 134 206 3.86568e-17
C9_182 136 206 3.86568e-17
R9_19 133 134 624
C9_191 133 206 1.09528e-16
C9_192 134 206 1.09528e-16
R9_20 132 133 336
C9_201 132 206 5.79852e-17
C9_202 133 206 5.79852e-17
R9_21 140 145 13
C9_211 140 206 5.3574e-17
C9_212 145 206 5.3574e-17
R9_22 131 140 52
C9_221 131 206 1.39292e-16
C9_222 140 206 1.39292e-16
R9_23 128 131 39
C9_231 128 206 1.07148e-16
C9_232 131 206 1.07148e-16
R9_24 123 128 39
C9_241 123 206 9.64332e-17
C9_242 128 206 9.64332e-17
R8_1 149 148 15
R8_2 168 167 15
R8_3 169 167 15
R8_4 153 152 15
R8_5 158 157 15
R8_6 156 155 15
R8_7 162 163 15
R8_8 166 165 7.5
R8_9 165 164 384
C8_91 165 206 6.76494e-17
C8_92 164 206 6.76494e-17
R8_10 155 166 65
C8_101 155 206 1.50007e-16
C8_102 166 206 1.50007e-16
R8_11 160 163 39
C8_111 160 206 1.07148e-16
C8_112 163 206 1.07148e-16
R8_12 160 161 26
C8_121 160 206 6.42888e-17
C8_122 161 206 6.42888e-17
R8_13 156 159 144
C8_131 156 206 2.57712e-17
C8_132 159 206 2.57712e-17
R8_14 151 156 336
C8_141 151 206 6.12066e-17
C8_142 156 206 6.12066e-17
R8_15 157 161 13
C8_151 157 206 4.28592e-17
C8_152 161 206 4.28592e-17
R8_16 158 159 624
C8_161 158 206 1.09528e-16
C8_162 159 206 1.09528e-16
R8_17 154 158 192
C8_171 154 206 3.78515e-17
C8_172 158 206 3.78515e-17
R8_18 150 154 288
C8_181 150 206 5.47638e-17
C8_182 154 206 5.47638e-17
R8_19 153 154 720
C8_191 153 206 1.22413e-16
C8_192 154 206 1.22413e-16
R8_20 168 169 13
C8_201 168 206 5.3574e-17
C8_202 169 206 5.3574e-17
R8_21 152 168 104
C8_211 152 206 2.4644e-16
C8_212 168 206 2.4644e-16
R8_22 149 152 39
C8_221 149 206 9.64332e-17
C8_222 152 206 9.64332e-17
R7_1 175 173 15
R7_2 174 175 672
C7_21 174 206 1.19192e-16
C7_22 175 206 1.19192e-16
R7_3 175 177 624
C7_31 175 206 1.06306e-16
C7_32 177 206 1.06306e-16
R7_4 175 176 624
C7_41 175 206 1.06306e-16
C7_42 176 206 1.06306e-16
R7_5 172 175 672
C7_51 172 206 1.19192e-16
C7_52 175 206 1.19192e-16
R6_1 181 180 15
R6_2 183 180 15
R6_3 183 184 288
C6_31 183 206 4.8321e-17
C6_32 184 206 4.8321e-17
R6_4 182 181 336
C6_41 182 206 6.12066e-17
C6_42 181 206 6.12066e-17
R4_1 191 190 15
R4_2 197 196 15
R4_3 201 200 15
R4_4 199 198 15
R4_5 202 203 15
R4_6 193 194 15
R4_7 198 203 65
C4_71 198 206 1.60722e-16
C4_72 203 206 1.60722e-16
R4_8 194 198 39
C4_81 194 206 9.64332e-17
C4_82 198 206 9.64332e-17
R4_9 196 199 1248
C4_91 196 206 2.12612e-16
C4_92 199 206 2.12612e-16
R4_10 195 201 78
C4_101 195 206 2.03581e-16
C4_102 201 206 2.03581e-16
R4_11 195 197 26
C4_111 195 206 7.50036e-17
C4_112 197 206 7.50036e-17
R4_12 192 197 65
C4_121 192 206 1.50007e-16
C4_122 197 206 1.50007e-16
R4_13 191 192 26
C4_131 191 206 7.50036e-17
C4_132 192 206 7.50036e-17
R3_1 214 207 15
R3_2 219 212 15
R3_3 221 212 15
R3_4 220 213 15
R3_5 222 213 15
R3_6 218 211 15
R3_7 215 208 15
R3_8 217 210 15
R3_9 216 209 15
R3_10 206 216 26
C3_101 206 206 6.42888e-17
C3_102 216 206 6.42888e-17
R3_11 206 217 26
C3_111 206 206 6.42888e-17
C3_112 217 206 6.42888e-17
R3_12 206 215 26
C3_121 206 206 6.42888e-17
C3_122 215 206 6.42888e-17
R3_13 206 218 26
C3_131 206 206 6.42888e-17
C3_132 218 206 6.42888e-17
R3_14 220 222 26
C3_141 220 206 6.42888e-17
C3_142 222 206 6.42888e-17
R3_15 206 220 26
C3_151 206 206 6.42888e-17
C3_152 220 206 6.42888e-17
R3_16 219 221 13
C3_161 219 206 4.28592e-17
C3_162 221 206 4.28592e-17
R3_17 206 219 26
C3_171 206 206 6.42888e-17
C3_172 219 206 6.42888e-17
R3_18 206 214 26
C3_181 206 206 6.42888e-17
C3_182 214 206 6.42888e-17
R1_1 229 228 15
R1_2 234 233 15
R1_3 231 232 15
R1_4 236 237 15
R1_5 237 239 39
C1_51 237 206 9.64332e-17
C1_52 239 206 9.64332e-17
R1_6 238 239 39
C1_61 238 206 1.07148e-16
C1_62 239 206 1.07148e-16
R1_7 235 238 13
C1_71 235 206 5.3574e-17
C1_72 238 206 5.3574e-17
R1_8 230 232 65
C1_81 230 206 1.50007e-16
C1_82 232 206 1.50007e-16
R1_9 234 235 52
C1_91 234 206 1.28578e-16
C1_92 235 206 1.28578e-16
R1_10 230 234 130
C1_101 230 206 3.00014e-16
C1_102 234 206 3.00014e-16
R1_11 229 230 13
C1_111 229 206 5.3574e-17
C1_112 230 206 5.3574e-17
.ends sff2_x4
