* Spice description of a2_x2
* Spice driver version -703026259
* Date ( dd/mm/yyyy hh:mm:ss ):  8/05/2026 at 13:38:27

* INTERF i0 i1 q vdd vss

.subckt a2_x2 2 8 21 17 41
* NET 2 = i0
* NET 8 = i1
* NET 17 = vdd
* NET 21 = q
* NET 41 = vss
Mtr_00006 22 32 13 17 sky130_fd_pr__pfet_01v8__model L=0.15U W=2.46U AS=0.7134P AD=0.7134P PS=5.5U PD=5.5U
Mtr_00005 33 4 13 17 sky130_fd_pr__pfet_01v8__model L=0.15U W=1.26U AS=0.3654P AD=0.3654P PS=3.1U PD=3.1U
Mtr_00004 14 10 33 17 sky130_fd_pr__pfet_01v8__model L=0.15U W=1.26U AS=0.3654P AD=0.3654P PS=3.1U PD=3.1U
Mtr_00003 42 25 20 41 sky130_fd_pr__nfet_01v8__model L=0.15U W=1.26U AS=0.3654P AD=0.3654P PS=3.1U PD=3.1U
Mtr_00002 38 7 27 41 sky130_fd_pr__nfet_01v8__model L=0.15U W=1.26U AS=0.3654P AD=0.3654P PS=3.1U PD=3.1U
Mtr_00001 42 1 38 41 sky130_fd_pr__nfet_01v8__model L=0.15U W=1.26U AS=0.3654P AD=0.3654P PS=3.1U PD=3.1U
R7_1 3 2 15
R7_2 3 4 672
C7_21 3 41 1.12749e-16
C7_22 4 41 1.12749e-16
R7_3 1 3 480
C7_31 1 41 8.69778e-17
C7_32 3 41 8.69778e-17
R6_1 9 8 15
R6_2 9 10 672
C6_21 9 41 1.12749e-16
C6_22 10 41 1.12749e-16
R6_3 7 9 480
C6_31 7 41 8.69778e-17
C6_32 9 41 8.69778e-17
R5_1 15 13 15
R5_2 16 14 15
R5_3 16 17 26
C5_31 16 41 6.42888e-17
C5_32 17 41 6.42888e-17
R5_4 15 17 26
C5_41 15 41 6.42888e-17
C5_42 17 41 6.42888e-17
R4_1 21 20 7.5
R4_2 21 22 3.75
R3_1 28 27 15
R3_2 34 33 15
R3_3 35 33 15
R3_4 30 29 15
R3_5 30 32 672
C3_51 30 41 1.12749e-16
C3_52 32 41 1.12749e-16
R3_6 25 30 288
C3_61 25 41 5.47638e-17
C3_62 30 41 5.47638e-17
R3_7 29 31 26
C3_71 29 41 7.50036e-17
C3_72 31 41 7.50036e-17
R3_8 34 35 26
C3_81 34 41 7.50036e-17
C3_82 35 41 7.50036e-17
R3_9 31 34 78
C3_91 31 41 2.03581e-16
C3_92 34 41 2.03581e-16
R3_10 26 31 52
C3_101 26 41 1.28578e-16
C3_102 31 41 1.28578e-16
R3_11 26 28 26
C3_111 26 41 6.42888e-17
C3_112 28 41 6.42888e-17
R1_1 44 42 15
R1_2 43 42 15
R1_3 43 44 26
C1_31 43 41 7.50036e-17
C1_32 44 41 7.50036e-17
R1_4 41 43 26
C1_41 41 41 6.42888e-17
C1_42 43 41 6.42888e-17
.ends a2_x2
