* Spice description of noa2a2a2a24_x1
* Spice driver version -1743123539
* Date ( dd/mm/yyyy hh:mm:ss ):  8/05/2026 at 14:22:51

* INTERF i0 i1 i2 i3 i4 i5 i6 i7 nq vdd vss

.subckt noa2a2a2a24_x1 58 52 48 41 1 13 7 20 89 66 98
* NET 1 = i4
* NET 7 = i6
* NET 13 = i5
* NET 20 = i7
* NET 41 = i3
* NET 48 = i2
* NET 52 = i1
* NET 58 = i0
* NET 66 = vdd
* NET 89 = nq
* NET 98 = vss
Mtr_00016 80 4 25 66 sky130_fd_pr__pfet_01v8__model L=0.15U W=2.46U AS=0.7134P AD=0.7134P PS=5.5U PD=5.5U
Mtr_00015 94 10 26 66 sky130_fd_pr__pfet_01v8__model L=0.15U W=2.46U AS=0.7134P AD=0.7134P PS=5.5U PD=5.5U
Mtr_00014 27 21 94 66 sky130_fd_pr__pfet_01v8__model L=0.15U W=2.46U AS=0.7134P AD=0.7134P PS=5.5U PD=5.5U
Mtr_00013 26 16 80 66 sky130_fd_pr__pfet_01v8__model L=0.15U W=2.46U AS=0.7134P AD=0.7134P PS=5.5U PD=5.5U
Mtr_00012 79 42 70 66 sky130_fd_pr__pfet_01v8__model L=0.15U W=2.46U AS=0.7134P AD=0.7134P PS=5.5U PD=5.5U
Mtr_00011 71 46 79 66 sky130_fd_pr__pfet_01v8__model L=0.15U W=2.46U AS=0.7134P AD=0.7134P PS=5.5U PD=5.5U
Mtr_00010 70 55 64 66 sky130_fd_pr__pfet_01v8__model L=0.15U W=2.46U AS=0.7134P AD=0.7134P PS=5.5U PD=5.5U
Mtr_00009 64 61 69 66 sky130_fd_pr__pfet_01v8__model L=0.15U W=2.46U AS=0.7134P AD=0.7134P PS=5.5U PD=5.5U
Mtr_00008 37 19 105 98 sky130_fd_pr__nfet_01v8__model L=0.15U W=1.26U AS=0.3654P AD=0.3654P PS=3.1U PD=3.1U
Mtr_00007 90 8 37 98 sky130_fd_pr__nfet_01v8__model L=0.15U W=1.26U AS=0.3654P AD=0.3654P PS=3.1U PD=3.1U
Mtr_00006 34 14 90 98 sky130_fd_pr__nfet_01v8__model L=0.15U W=1.26U AS=0.3654P AD=0.3654P PS=3.1U PD=3.1U
Mtr_00005 102 2 34 98 sky130_fd_pr__nfet_01v8__model L=0.15U W=1.26U AS=0.3654P AD=0.3654P PS=3.1U PD=3.1U
Mtr_00004 85 47 101 98 sky130_fd_pr__nfet_01v8__model L=0.15U W=1.26U AS=0.3654P AD=0.3654P PS=3.1U PD=3.1U
Mtr_00003 88 40 85 98 sky130_fd_pr__nfet_01v8__model L=0.15U W=1.26U AS=0.3654P AD=0.3654P PS=3.1U PD=3.1U
Mtr_00002 109 53 88 98 sky130_fd_pr__nfet_01v8__model L=0.15U W=1.26U AS=0.3654P AD=0.3654P PS=3.1U PD=3.1U
Mtr_00001 99 59 109 98 sky130_fd_pr__nfet_01v8__model L=0.15U W=1.26U AS=0.3654P AD=0.3654P PS=3.1U PD=3.1U
R18_1 3 1 15
R18_2 3 4 528
C18_21 3 98 9.34206e-17
C18_22 4 98 9.34206e-17
R18_3 2 3 432
C18_31 2 98 7.40922e-17
C18_32 3 98 7.40922e-17
R17_1 9 7 15
R17_2 9 10 528
C17_21 9 98 9.34206e-17
C17_22 10 98 9.34206e-17
R17_3 8 9 432
C17_31 8 98 7.40922e-17
C17_32 9 98 7.40922e-17
R16_1 15 13 15
R16_2 15 16 528
C16_21 15 98 9.34206e-17
C16_22 16 98 9.34206e-17
R16_3 14 15 432
C16_31 14 98 7.40922e-17
C16_32 15 98 7.40922e-17
R15_1 22 20 15
R15_2 22 21 528
C15_21 22 98 9.34206e-17
C15_22 21 98 9.34206e-17
R15_3 19 22 432
C15_31 19 98 7.40922e-17
C15_32 22 98 7.40922e-17
R14_1 29 26 15
R14_2 30 26 15
R14_3 28 25 15
R14_4 31 27 15
R14_5 30 31 52
C14_51 30 98 1.28578e-16
C14_52 31 98 1.28578e-16
R14_6 29 30 13
C14_61 29 98 5.3574e-17
C14_62 30 98 5.3574e-17
R14_7 28 29 52
C14_71 28 98 1.28578e-16
C14_72 29 98 1.28578e-16
R11_1 43 41 15
R11_2 43 42 528
C11_21 43 98 9.34206e-17
C11_22 42 98 9.34206e-17
R11_3 40 43 432
C11_31 40 98 7.40922e-17
C11_32 43 98 7.40922e-17
R10_1 49 48 15
R10_2 49 46 528
C10_21 49 98 9.34206e-17
C10_22 46 98 9.34206e-17
R10_3 47 49 432
C10_31 47 98 7.40922e-17
C10_32 49 98 7.40922e-17
R9_1 54 52 15
R9_2 54 55 528
C9_21 54 98 9.34206e-17
C9_22 55 98 9.34206e-17
R9_3 53 54 432
C9_31 53 98 7.40922e-17
C9_32 54 98 7.40922e-17
R8_1 60 58 15
R8_2 60 61 528
C8_21 60 98 9.34206e-17
C8_22 61 98 9.34206e-17
R8_3 59 60 432
C8_31 59 98 7.40922e-17
C8_32 60 98 7.40922e-17
R7_1 65 64 15
R7_2 65 66 26
C7_21 65 98 6.42888e-17
C7_22 66 98 6.42888e-17
R6_1 73 70 15
R6_2 76 70 15
R6_3 74 71 15
R6_4 72 69 15
R6_5 75 69 15
R6_6 72 75 13
C6_61 72 98 5.3574e-17
C6_62 75 98 5.3574e-17
R6_7 73 76 13
C6_71 73 98 5.3574e-17
C6_72 76 98 5.3574e-17
R6_8 73 74 52
C6_81 73 98 1.28578e-16
C6_82 74 98 1.28578e-16
R6_9 72 73 52
C6_91 72 98 1.28578e-16
C6_92 73 98 1.28578e-16
R5_1 81 79 15
R5_2 82 80 15
R5_3 81 82 78
C5_31 81 98 1.92866e-16
C5_32 82 98 1.92866e-16
R3_1 89 88 7.5
R3_2 91 90 15
R3_3 95 94 15
R3_4 92 90 15
R3_5 92 91 13
C3_51 92 98 5.3574e-17
C3_52 91 98 5.3574e-17
R3_6 93 95 130
C3_61 93 98 3.00014e-16
C3_62 95 98 3.00014e-16
R3_7 91 93 26
C3_71 91 98 6.42888e-17
C3_72 93 98 6.42888e-17
R3_8 89 91 130
C3_81 89 98 3.21444e-16
C3_82 91 98 3.21444e-16
R2_1 100 99 15
R2_2 103 101 15
R2_3 104 102 15
R2_4 106 105 15
R2_5 98 106 26
C2_51 98 98 6.42888e-17
C2_52 106 98 6.42888e-17
R2_6 98 104 26
C2_61 98 98 6.42888e-17
C2_62 104 98 6.42888e-17
R2_7 98 103 26
C2_71 98 98 6.42888e-17
C2_72 103 98 6.42888e-17
R2_8 98 100 26
C2_81 98 98 6.42888e-17
C2_82 100 98 6.42888e-17
.ends noa2a2a2a24_x1
