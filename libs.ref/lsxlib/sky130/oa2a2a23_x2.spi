* Spice description of oa2a2a23_x2
* Spice driver version 2113973165
* Date ( dd/mm/yyyy hh:mm:ss ):  8/05/2026 at 14:22:51

* INTERF i0 i1 i2 i3 i4 i5 q vdd vss

.subckt oa2a2a23_x2 48 66 55 61 24 18 41 37 95
* NET 18 = i5
* NET 24 = i4
* NET 37 = vdd
* NET 41 = q
* NET 48 = i0
* NET 55 = i2
* NET 61 = i3
* NET 66 = i1
* NET 95 = vss
Mtr_00014 30 85 42 37 sky130_fd_pr__pfet_01v8__model L=0.15U W=2.46U AS=0.7134P AD=0.7134P PS=5.5U PD=5.5U
Mtr_00013 11 63 2 37 sky130_fd_pr__pfet_01v8__model L=0.15U W=1.26U AS=0.3654P AD=0.3654P PS=3.1U PD=3.1U
Mtr_00012 3 57 11 37 sky130_fd_pr__pfet_01v8__model L=0.15U W=1.26U AS=0.3654P AD=0.3654P PS=3.1U PD=3.1U
Mtr_00011 2 69 86 37 sky130_fd_pr__pfet_01v8__model L=0.15U W=1.26U AS=0.3654P AD=0.3654P PS=3.1U PD=3.1U
Mtr_00010 30 27 13 37 sky130_fd_pr__pfet_01v8__model L=0.15U W=1.26U AS=0.3654P AD=0.3654P PS=3.1U PD=3.1U
Mtr_00009 13 21 33 37 sky130_fd_pr__pfet_01v8__model L=0.15U W=1.26U AS=0.3654P AD=0.3654P PS=3.1U PD=3.1U
Mtr_00008 86 51 1 37 sky130_fd_pr__pfet_01v8__model L=0.15U W=1.26U AS=0.3654P AD=0.3654P PS=3.1U PD=3.1U
Mtr_00007 40 81 100 95 sky130_fd_pr__nfet_01v8__model L=0.15U W=1.26U AS=0.3654P AD=0.3654P PS=3.1U PD=3.1U
Mtr_00006 45 25 100 95 sky130_fd_pr__nfet_01v8__model L=0.15U W=0.66U AS=0.1914P AD=0.1914P PS=1.9U PD=1.9U
Mtr_00005 72 54 98 95 sky130_fd_pr__nfet_01v8__model L=0.15U W=0.66U AS=0.1914P AD=0.1914P PS=1.9U PD=1.9U
Mtr_00004 75 60 72 95 sky130_fd_pr__nfet_01v8__model L=0.15U W=0.66U AS=0.1914P AD=0.1914P PS=1.9U PD=1.9U
Mtr_00003 92 67 75 95 sky130_fd_pr__nfet_01v8__model L=0.15U W=0.66U AS=0.1914P AD=0.1914P PS=1.9U PD=1.9U
Mtr_00002 96 49 92 95 sky130_fd_pr__nfet_01v8__model L=0.15U W=0.66U AS=0.1914P AD=0.1914P PS=1.9U PD=1.9U
Mtr_00001 78 20 45 95 sky130_fd_pr__nfet_01v8__model L=0.15U W=0.66U AS=0.1914P AD=0.1914P PS=1.9U PD=1.9U
R15_1 7 2 15
R15_2 5 2 15
R15_3 8 3 15
R15_4 6 1 15
R15_5 4 1 15
R15_6 4 6 13
C15_61 4 95 5.3574e-17
C15_62 6 95 5.3574e-17
R15_7 7 8 52
C15_71 7 95 1.28578e-16
C15_72 8 95 1.28578e-16
R15_8 6 7 52
C15_81 6 95 1.28578e-16
C15_82 7 95 1.28578e-16
R15_9 5 7 13
C15_91 5 95 5.3574e-17
C15_92 7 95 5.3574e-17
R14_1 12 11 15
R14_2 14 13 15
R14_3 15 13 15
R14_4 14 15 13
C14_41 14 95 5.3574e-17
C14_42 15 95 5.3574e-17
R14_5 12 14 78
C14_51 12 95 1.92866e-16
C14_52 14 95 1.92866e-16
R13_1 19 18 15
R13_2 19 21 720
C13_21 19 95 1.25635e-16
C13_22 21 95 1.25635e-16
R13_3 20 19 528
C13_31 20 95 9.01992e-17
C13_32 19 95 9.01992e-17
R12_1 26 24 15
R12_2 26 27 720
C12_21 26 95 1.25635e-16
C12_22 27 95 1.25635e-16
R12_3 25 26 528
C12_31 25 95 9.01992e-17
C12_32 26 95 9.01992e-17
R11_1 30 31 15
R11_2 34 30 15
R11_3 32 30 15
R11_4 36 30 15
R11_5 35 33 15
R11_6 35 37 26
C11_61 35 95 6.42888e-17
C11_62 37 95 6.42888e-17
R11_7 36 37 26
C11_71 36 95 6.42888e-17
C11_72 37 95 6.42888e-17
R11_8 34 36 13
C11_81 34 95 5.3574e-17
C11_82 36 95 5.3574e-17
R11_9 32 34 26
C11_91 32 95 6.42888e-17
C11_92 34 95 6.42888e-17
R11_10 31 32 26
C11_101 31 95 6.42888e-17
C11_102 32 95 6.42888e-17
R10_1 41 40 7.5
R10_2 41 42 3.75
R8_1 50 48 15
R8_2 50 51 720
C8_21 50 95 1.25635e-16
C8_22 51 95 1.25635e-16
R8_3 49 50 528
C8_31 49 95 9.01992e-17
C8_32 50 95 9.01992e-17
R7_1 56 55 15
R7_2 56 57 720
C7_21 56 95 1.25635e-16
C7_22 57 95 1.25635e-16
R7_3 54 56 528
C7_31 54 95 9.01992e-17
C7_32 56 95 9.01992e-17
R6_1 62 61 15
R6_2 62 63 720
C6_21 62 95 1.25635e-16
C6_22 63 95 1.25635e-16
R6_3 60 62 528
C6_31 60 95 9.01992e-17
C6_32 62 95 9.01992e-17
R5_1 68 66 15
R5_2 68 69 720
C5_21 68 95 1.25635e-16
C5_22 69 95 1.25635e-16
R5_3 67 68 528
C5_31 67 95 9.01992e-17
C5_32 68 95 9.01992e-17
R3_1 76 75 15
R3_2 89 86 15
R3_3 79 78 15
R3_4 84 83 15
R3_5 84 85 528
C3_51 84 95 9.34206e-17
C3_52 85 95 9.34206e-17
R3_6 81 84 432
C3_61 81 95 7.40922e-17
C3_62 84 95 7.40922e-17
R3_7 82 83 39
C3_71 82 95 1.07148e-16
C3_72 83 95 1.07148e-16
R3_8 79 80 13
C3_81 79 95 5.3574e-17
C3_82 80 95 5.3574e-17
R3_9 88 89 13
C3_91 88 95 5.3574e-17
C3_92 89 95 5.3574e-17
R3_10 80 82 52
C3_101 80 95 1.39292e-16
C3_102 82 95 1.39292e-16
R3_11 77 80 78
C3_111 77 95 1.92866e-16
C3_112 80 95 1.92866e-16
R3_12 88 87 26
C3_121 88 95 6.42888e-17
C3_122 87 95 6.42888e-17
R3_13 77 87 104
C3_131 77 95 2.4644e-16
C3_132 87 95 2.4644e-16
R3_14 76 77 13
C3_141 76 95 5.3574e-17
C3_142 77 95 5.3574e-17
R1_1 97 96 15
R1_2 99 98 15
R1_3 101 100 15
R1_4 95 101 26
C1_41 95 95 6.42888e-17
C1_42 101 95 6.42888e-17
R1_5 95 99 26
C1_51 95 95 6.42888e-17
C1_52 99 95 6.42888e-17
R1_6 95 97 26
C1_61 95 95 6.42888e-17
C1_62 97 95 6.42888e-17
.ends oa2a2a23_x2
