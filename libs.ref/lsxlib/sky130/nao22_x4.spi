* Spice description of nao22_x4
* Spice driver version 1317747629
* Date ( dd/mm/yyyy hh:mm:ss ):  8/05/2026 at 14:22:51

* INTERF i0 i1 i2 nq vdd vss

.subckt nao22_x4 19 31 25 50 46 70
* NET 19 = i0
* NET 25 = i2
* NET 31 = i1
* NET 46 = vdd
* NET 50 = nq
* NET 70 = vss
Mtr_00012 38 65 14 46 sky130_fd_pr__pfet_01v8__model L=0.15U W=1.26U AS=0.3654P AD=0.3654P PS=3.1U PD=3.1U
Mtr_00011 37 28 62 46 sky130_fd_pr__pfet_01v8__model L=0.15U W=1.26U AS=0.3654P AD=0.3654P PS=3.1U PD=3.1U
Mtr_00010 1 22 41 46 sky130_fd_pr__pfet_01v8__model L=0.15U W=1.26U AS=0.3654P AD=0.3654P PS=3.1U PD=3.1U
Mtr_00009 62 34 1 46 sky130_fd_pr__pfet_01v8__model L=0.15U W=1.26U AS=0.3654P AD=0.3654P PS=3.1U PD=3.1U
Mtr_00008 37 10 51 46 sky130_fd_pr__pfet_01v8__model L=0.15U W=2.46U AS=0.7134P AD=0.7134P PS=5.5U PD=5.5U
Mtr_00007 51 11 38 46 sky130_fd_pr__pfet_01v8__model L=0.15U W=2.46U AS=0.7134P AD=0.7134P PS=5.5U PD=5.5U
Mtr_00006 6 57 73 70 sky130_fd_pr__nfet_01v8__model L=0.15U W=0.66U AS=0.1914P AD=0.1914P PS=1.9U PD=1.9U
Mtr_00005 80 26 71 70 sky130_fd_pr__nfet_01v8__model L=0.15U W=0.66U AS=0.1914P AD=0.1914P PS=1.9U PD=1.9U
Mtr_00004 54 32 80 70 sky130_fd_pr__nfet_01v8__model L=0.15U W=0.66U AS=0.1914P AD=0.1914P PS=1.9U PD=1.9U
Mtr_00003 78 20 54 70 sky130_fd_pr__nfet_01v8__model L=0.15U W=0.66U AS=0.1914P AD=0.1914P PS=1.9U PD=1.9U
Mtr_00002 73 5 49 70 sky130_fd_pr__nfet_01v8__model L=0.15U W=1.26U AS=0.3654P AD=0.3654P PS=3.1U PD=3.1U
Mtr_00001 49 4 71 70 sky130_fd_pr__nfet_01v8__model L=0.15U W=1.26U AS=0.3654P AD=0.3654P PS=3.1U PD=3.1U
R9_1 9 8 15
R9_2 16 14 15
R9_3 15 14 15
R9_4 7 6 15
R9_5 13 12 15
R9_6 11 13 288
C9_61 11 70 5.15424e-17
C9_62 13 70 5.15424e-17
R9_7 10 11 192
C9_71 10 70 3.86568e-17
C9_72 11 70 3.86568e-17
R9_8 15 16 26
C9_81 15 70 7.50036e-17
C9_82 16 70 7.50036e-17
R9_9 12 15 52
C9_91 12 70 1.39292e-16
C9_92 15 70 1.39292e-16
R9_10 8 12 26
C9_101 8 70 8.57184e-17
C9_102 12 70 8.57184e-17
R9_11 7 8 39
C9_111 7 70 1.07148e-16
C9_112 8 70 1.07148e-16
R9_12 5 9 288
C9_121 5 70 5.15424e-17
C9_122 9 70 5.15424e-17
R9_13 4 5 192
C9_131 4 70 3.86568e-17
C9_132 5 70 3.86568e-17
R8_1 21 19 15
R8_2 21 22 768
C8_21 21 70 1.32077e-16
C8_22 22 70 1.32077e-16
R8_3 20 21 480
C8_31 20 70 8.37564e-17
C8_32 21 70 8.37564e-17
R7_1 27 25 15
R7_2 27 28 768
C7_21 27 70 1.32077e-16
C7_22 28 70 1.32077e-16
R7_3 26 27 480
C7_31 26 70 8.37564e-17
C7_32 27 70 8.37564e-17
R6_1 33 31 15
R6_2 33 34 768
C6_21 33 70 1.32077e-16
C6_22 34 70 1.32077e-16
R6_3 32 33 480
C6_31 32 70 8.37564e-17
C6_32 33 70 8.37564e-17
R5_1 44 37 15
R5_2 42 38 15
R5_3 40 38 15
R5_4 45 38 15
R5_5 39 38 15
R5_6 43 41 15
R5_7 43 46 26
C5_71 43 70 6.42888e-17
C5_72 46 70 6.42888e-17
R5_8 45 46 26
C5_81 45 70 6.42888e-17
C5_82 46 70 6.42888e-17
R5_9 42 45 26
C5_91 42 70 6.42888e-17
C5_92 45 70 6.42888e-17
R5_10 40 42 26
C5_101 40 70 6.42888e-17
C5_102 42 70 6.42888e-17
R5_11 39 40 13
C5_111 39 70 5.3574e-17
C5_112 40 70 5.3574e-17
R5_12 44 46 26
C5_121 44 70 6.42888e-17
C5_122 46 70 6.42888e-17
R4_1 50 49 7.5
R4_2 50 51 3.75
R3_1 55 54 15
R3_2 60 59 15
R3_3 63 62 15
R3_4 67 62 15
R3_5 57 58 192
C3_51 57 70 3.86568e-17
C3_52 58 70 3.86568e-17
R3_6 65 66 192
C3_61 65 70 3.86568e-17
C3_62 66 70 3.86568e-17
R3_7 61 66 528
C3_71 61 70 9.01992e-17
C3_72 66 70 9.01992e-17
R3_8 58 61 336
C3_81 58 70 5.79852e-17
C3_82 61 70 5.79852e-17
R3_9 60 61 768
C3_91 60 70 1.28856e-16
C3_92 61 70 1.28856e-16
R3_10 63 67 13
C3_101 63 70 5.3574e-17
C3_102 67 70 5.3574e-17
R3_11 63 64 26
C3_111 63 70 7.50036e-17
C3_112 64 70 7.50036e-17
R3_12 59 64 78
C3_121 59 70 2.03581e-16
C3_122 64 70 2.03581e-16
R3_13 56 59 39
C3_131 56 70 9.64332e-17
C3_132 59 70 9.64332e-17
R3_14 55 56 52
C3_141 55 70 1.39292e-16
C3_142 56 70 1.39292e-16
R2_1 72 71 15
R2_2 75 73 15
R2_3 74 73 15
R2_4 74 75 26
C2_41 74 70 7.50036e-17
C2_42 75 70 7.50036e-17
R2_5 70 74 26
C2_51 70 70 6.42888e-17
C2_52 74 70 6.42888e-17
R2_6 70 72 26
C2_61 70 70 6.42888e-17
C2_62 72 70 6.42888e-17
R1_1 81 80 15
R1_2 79 78 7.5
R1_3 79 81 52
C1_31 79 70 1.28578e-16
C1_32 81 70 1.28578e-16
.ends nao22_x4
