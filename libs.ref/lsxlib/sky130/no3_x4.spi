* Spice description of no3_x4
* Spice driver version 1025559469
* Date ( dd/mm/yyyy hh:mm:ss ):  8/05/2026 at 14:23:17

* INTERF i0 i1 i2 nq vdd vss

.subckt no3_x4 1 11 6 48 44 52
* NET 1 = i0
* NET 6 = i2
* NET 11 = i1
* NET 44 = vdd
* NET 48 = nq
* NET 52 = vss
Mtr_00012 38 78 26 44 sky130_fd_pr__pfet_01v8__model L=0.15U W=1.26U AS=0.3654P AD=0.3654P PS=3.1U PD=3.1U
Mtr_00011 31 3 74 44 sky130_fd_pr__pfet_01v8__model L=0.15U W=2.46U AS=0.7134P AD=0.7134P PS=5.5U PD=5.5U
Mtr_00010 37 8 34 44 sky130_fd_pr__pfet_01v8__model L=0.15U W=2.46U AS=0.7134P AD=0.7134P PS=5.5U PD=5.5U
Mtr_00009 34 13 31 44 sky130_fd_pr__pfet_01v8__model L=0.15U W=2.46U AS=0.7134P AD=0.7134P PS=5.5U PD=5.5U
Mtr_00008 49 23 38 44 sky130_fd_pr__pfet_01v8__model L=0.15U W=2.46U AS=0.7134P AD=0.7134P PS=5.5U PD=5.5U
Mtr_00007 37 22 49 44 sky130_fd_pr__pfet_01v8__model L=0.15U W=2.46U AS=0.7134P AD=0.7134P PS=5.5U PD=5.5U
Mtr_00006 18 69 57 52 sky130_fd_pr__nfet_01v8__model L=0.15U W=0.66U AS=0.1914P AD=0.1914P PS=1.9U PD=1.9U
Mtr_00005 62 2 53 52 sky130_fd_pr__nfet_01v8__model L=0.15U W=0.66U AS=0.1914P AD=0.1914P PS=1.9U PD=1.9U
Mtr_00004 57 17 47 52 sky130_fd_pr__nfet_01v8__model L=0.15U W=1.26U AS=0.3654P AD=0.3654P PS=3.1U PD=3.1U
Mtr_00003 47 16 55 52 sky130_fd_pr__nfet_01v8__model L=0.15U W=1.26U AS=0.3654P AD=0.3654P PS=3.1U PD=3.1U
Mtr_00002 65 7 55 52 sky130_fd_pr__nfet_01v8__model L=0.15U W=0.66U AS=0.1914P AD=0.1914P PS=1.9U PD=1.9U
Mtr_00001 53 12 65 52 sky130_fd_pr__nfet_01v8__model L=0.15U W=0.66U AS=0.1914P AD=0.1914P PS=1.9U PD=1.9U
R10_1 3 1 15
R10_2 2 3 1008
C10_21 2 52 1.75566e-16
C10_22 3 52 1.75566e-16
R9_1 8 6 15
R9_2 7 8 1008
C9_21 7 52 1.75566e-16
C9_22 8 52 1.75566e-16
R8_1 13 11 15
R8_2 12 13 1008
C8_21 12 52 1.75566e-16
C8_22 13 52 1.75566e-16
R7_1 21 20 15
R7_2 27 26 15
R7_3 28 26 15
R7_4 19 18 15
R7_5 25 24 15
R7_6 23 25 288
C7_61 23 52 5.15424e-17
C7_62 25 52 5.15424e-17
R7_7 22 23 192
C7_71 22 52 3.86568e-17
C7_72 23 52 3.86568e-17
R7_8 27 28 26
C7_81 27 52 7.50036e-17
C7_82 28 52 7.50036e-17
R7_9 24 27 52
C7_91 24 52 1.39292e-16
C7_92 27 52 1.39292e-16
R7_10 20 24 26
C7_101 20 52 8.57184e-17
C7_102 24 52 8.57184e-17
R7_11 19 20 39
C7_111 19 52 1.07148e-16
C7_112 20 52 1.07148e-16
R7_12 17 21 288
C7_121 17 52 5.15424e-17
C7_122 21 52 5.15424e-17
R7_13 16 17 192
C7_131 16 52 3.86568e-17
C7_132 17 52 3.86568e-17
R4_1 42 37 15
R4_2 43 38 15
R4_3 41 38 15
R4_4 40 38 15
R4_5 39 38 15
R4_6 43 44 26
C4_61 43 52 6.42888e-17
C4_62 44 52 6.42888e-17
R4_7 41 43 26
C4_71 41 52 6.42888e-17
C4_72 43 52 6.42888e-17
R4_8 40 41 26
C4_81 40 52 6.42888e-17
C4_82 41 52 6.42888e-17
R4_9 39 40 13
C4_91 39 52 5.3574e-17
C4_92 40 52 5.3574e-17
R4_10 42 44 26
C4_101 42 52 6.42888e-17
C4_102 44 52 6.42888e-17
R3_1 48 47 7.5
R3_2 48 49 3.75
R2_1 54 53 15
R2_2 59 57 15
R2_3 58 57 15
R2_4 56 55 15
R2_5 52 56 26
C2_51 52 52 6.42888e-17
C2_52 56 52 6.42888e-17
R2_6 58 59 26
C2_61 58 52 7.50036e-17
C2_62 59 52 7.50036e-17
R2_7 52 58 26
C2_71 52 52 6.42888e-17
C2_72 58 52 6.42888e-17
R2_8 52 54 26
C2_81 52 52 6.42888e-17
C2_82 54 52 6.42888e-17
R1_1 63 62 15
R1_2 72 71 15
R1_3 66 65 15
R1_4 80 74 15
R1_5 75 74 15
R1_6 69 70 192
C1_61 69 52 3.86568e-17
C1_62 70 52 3.86568e-17
R1_7 78 79 192
C1_71 78 52 3.86568e-17
C1_72 79 52 3.86568e-17
R1_8 75 80 13
C1_81 75 52 5.3574e-17
C1_82 80 52 5.3574e-17
R1_9 73 79 528
C1_91 73 52 9.01992e-17
C1_92 79 52 9.01992e-17
R1_10 70 73 336
C1_101 70 52 5.79852e-17
C1_102 73 52 5.79852e-17
R1_11 80 81 52
C1_111 80 52 1.39292e-16
C1_112 81 52 1.39292e-16
R1_12 72 73 768
C1_121 72 52 1.28856e-16
C1_122 73 52 1.28856e-16
R1_13 76 81 13
C1_131 76 52 5.3574e-17
C1_132 81 52 5.3574e-17
R1_14 76 77 26
C1_141 76 52 6.42888e-17
C1_142 77 52 6.42888e-17
R1_15 66 67 13
C1_151 66 52 5.3574e-17
C1_152 67 52 5.3574e-17
R1_16 71 77 78
C1_161 71 52 2.03581e-16
C1_162 77 52 2.03581e-16
R1_17 68 71 39
C1_171 68 52 9.64332e-17
C1_172 71 52 9.64332e-17
R1_18 67 68 26
C1_181 67 52 7.50036e-17
C1_182 68 52 7.50036e-17
R1_19 64 67 52
C1_191 64 52 1.28578e-16
C1_192 67 52 1.28578e-16
R1_20 63 64 13
C1_201 63 52 5.3574e-17
C1_202 64 52 5.3574e-17
.ends no3_x4
