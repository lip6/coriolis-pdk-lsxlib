* Spice description of ao2o22_x2
* Spice driver version -534385747
* Date ( dd/mm/yyyy hh:mm:ss ):  8/05/2026 at 14:22:51

* INTERF i0 i1 i2 i3 q vdd vss

.subckt ao2o22_x2 36 31 25 43 20 16 73
* NET 16 = vdd
* NET 20 = q
* NET 25 = i2
* NET 31 = i1
* NET 36 = i0
* NET 43 = i3
* NET 73 = vss
Mtr_00010 21 66 7 16 sky130_fd_pr__pfet_01v8__model L=0.15U W=2.46U AS=0.7134P AD=0.7134P PS=5.5U PD=5.5U
Mtr_00009 1 39 10 16 sky130_fd_pr__pfet_01v8__model L=0.15U W=1.26U AS=0.3654P AD=0.3654P PS=3.1U PD=3.1U
Mtr_00008 4 27 67 16 sky130_fd_pr__pfet_01v8__model L=0.15U W=1.26U AS=0.3654P AD=0.3654P PS=3.1U PD=3.1U
Mtr_00007 11 45 4 16 sky130_fd_pr__pfet_01v8__model L=0.15U W=1.26U AS=0.3654P AD=0.3654P PS=3.1U PD=3.1U
Mtr_00006 67 33 1 16 sky130_fd_pr__pfet_01v8__model L=0.15U W=1.26U AS=0.3654P AD=0.3654P PS=3.1U PD=3.1U
Mtr_00005 76 60 19 73 sky130_fd_pr__nfet_01v8__model L=0.15U W=1.26U AS=0.3654P AD=0.3654P PS=3.1U PD=3.1U
Mtr_00004 50 24 74 73 sky130_fd_pr__nfet_01v8__model L=0.15U W=0.66U AS=0.1914P AD=0.1914P PS=1.9U PD=1.9U
Mtr_00003 74 42 52 73 sky130_fd_pr__nfet_01v8__model L=0.15U W=0.66U AS=0.1914P AD=0.1914P PS=1.9U PD=1.9U
Mtr_00002 48 38 58 73 sky130_fd_pr__nfet_01v8__model L=0.15U W=0.66U AS=0.1914P AD=0.1914P PS=1.9U PD=1.9U
Mtr_00001 58 30 50 73 sky130_fd_pr__nfet_01v8__model L=0.15U W=0.66U AS=0.1914P AD=0.1914P PS=1.9U PD=1.9U
R9_1 7 8 15
R9_2 12 7 15
R9_3 9 7 15
R9_4 15 7 15
R9_5 14 11 15
R9_6 13 10 15
R9_7 13 16 26
C9_71 13 73 6.42888e-17
C9_72 16 73 6.42888e-17
R9_8 14 16 26
C9_81 14 73 6.42888e-17
C9_82 16 73 6.42888e-17
R9_9 15 16 26
C9_91 15 73 6.42888e-17
C9_92 16 73 6.42888e-17
R9_10 12 15 13
C9_101 12 73 5.3574e-17
C9_102 15 73 5.3574e-17
R9_11 9 12 26
C9_111 9 73 6.42888e-17
C9_112 12 73 6.42888e-17
R9_12 8 9 26
C9_121 8 73 6.42888e-17
C9_122 9 73 6.42888e-17
R8_1 20 19 7.5
R8_2 20 21 3.75
R7_1 26 25 15
R7_2 26 27 672
C7_21 26 73 1.19192e-16
C7_22 27 73 1.19192e-16
R7_3 24 26 576
C7_31 24 73 9.6642e-17
C7_32 26 73 9.6642e-17
R6_1 32 31 15
R6_2 32 33 672
C6_21 32 73 1.19192e-16
C6_22 33 73 1.19192e-16
R6_3 30 32 576
C6_31 30 73 9.6642e-17
C6_32 32 73 9.6642e-17
R5_1 37 36 15
R5_2 37 39 672
C5_21 37 73 1.19192e-16
C5_22 39 73 1.19192e-16
R5_3 38 37 576
C5_31 38 73 9.6642e-17
C5_32 37 73 9.6642e-17
R4_1 44 43 15
R4_2 44 45 672
C4_21 44 73 1.19192e-16
C4_22 45 73 1.19192e-16
R4_3 42 44 576
C4_31 42 73 9.6642e-17
C4_32 44 73 9.6642e-17
R3_1 51 50 15
R3_2 49 48 15
R3_3 53 52 15
R3_4 53 55 13
C3_41 53 73 5.3574e-17
C3_42 55 73 5.3574e-17
R3_5 54 55 52
C3_51 54 73 1.28578e-16
C3_52 55 73 1.28578e-16
R3_6 51 54 13
C3_61 51 73 5.3574e-17
C3_62 54 73 5.3574e-17
R3_7 49 51 52
C3_71 49 73 1.28578e-16
C3_72 51 73 1.28578e-16
R2_1 59 58 15
R2_2 68 67 15
R2_3 70 67 15
R2_4 65 64 15
R2_5 65 66 480
C2_51 65 73 8.69778e-17
C2_52 66 73 8.69778e-17
R2_6 60 65 480
C2_61 60 73 8.0535e-17
C2_62 65 73 8.0535e-17
R2_7 63 64 26
C2_71 63 73 6.42888e-17
C2_72 64 73 6.42888e-17
R2_8 63 69 78
C2_81 63 73 1.82152e-16
C2_82 69 73 1.82152e-16
R2_9 68 69 65
C2_91 68 73 1.60722e-16
C2_92 69 73 1.60722e-16
R2_10 68 70 26
C2_101 68 73 6.42888e-17
C2_102 70 73 6.42888e-17
R2_11 62 68 104
C2_111 62 73 2.35726e-16
C2_112 68 73 2.35726e-16
R2_12 61 62 26
C2_121 61 73 6.42888e-17
C2_122 62 73 6.42888e-17
R2_13 59 61 13
C2_131 59 73 5.3574e-17
C2_132 61 73 5.3574e-17
R1_1 75 74 15
R1_2 78 76 15
R1_3 77 76 15
R1_4 77 78 26
C1_41 77 73 7.50036e-17
C1_42 78 73 7.50036e-17
R1_5 73 77 26
C1_51 73 73 6.42888e-17
C1_52 77 73 6.42888e-17
R1_6 73 75 26
C1_61 73 73 6.42888e-17
C1_62 75 73 6.42888e-17
.ends ao2o22_x2
