* Spice description of o4_x2
* Spice driver version -1847653459
* Date ( dd/mm/yyyy hh:mm:ss ):  8/05/2026 at 14:22:51

* INTERF i0 i1 i2 i3 q vdd vss

.subckt o4_x2 8 25 13 19 2 38 66
* NET 2 = q
* NET 8 = i0
* NET 13 = i2
* NET 19 = i3
* NET 25 = i1
* NET 38 = vdd
* NET 66 = vss
Mtr_00010 44 14 41 38 sky130_fd_pr__pfet_01v8__model L=0.15U W=2.46U AS=0.7134P AD=0.7134P PS=5.5U PD=5.5U
Mtr_00009 59 20 44 38 sky130_fd_pr__pfet_01v8__model L=0.15U W=2.46U AS=0.7134P AD=0.7134P PS=5.5U PD=5.5U
Mtr_00008 30 26 41 38 sky130_fd_pr__pfet_01v8__model L=0.15U W=2.46U AS=0.7134P AD=0.7134P PS=5.5U PD=5.5U
Mtr_00007 33 6 30 38 sky130_fd_pr__pfet_01v8__model L=0.15U W=2.46U AS=0.7134P AD=0.7134P PS=5.5U PD=5.5U
Mtr_00006 3 58 33 38 sky130_fd_pr__pfet_01v8__model L=0.15U W=2.46U AS=0.7134P AD=0.7134P PS=5.5U PD=5.5U
Mtr_00005 69 12 48 66 sky130_fd_pr__nfet_01v8__model L=0.15U W=0.66U AS=0.1914P AD=0.1914P PS=1.9U PD=1.9U
Mtr_00004 48 18 67 66 sky130_fd_pr__nfet_01v8__model L=0.15U W=0.66U AS=0.1914P AD=0.1914P PS=1.9U PD=1.9U
Mtr_00003 51 7 71 66 sky130_fd_pr__nfet_01v8__model L=0.15U W=0.66U AS=0.1914P AD=0.1914P PS=1.9U PD=1.9U
Mtr_00002 69 24 51 66 sky130_fd_pr__nfet_01v8__model L=0.15U W=0.66U AS=0.1914P AD=0.1914P PS=1.9U PD=1.9U
Mtr_00001 1 55 71 66 sky130_fd_pr__nfet_01v8__model L=0.15U W=1.26U AS=0.3654P AD=0.3654P PS=3.1U PD=3.1U
R11_1 2 1 7.5
R11_2 2 3 3.75
R10_1 9 8 15
R10_2 9 6 480
C10_21 9 66 8.69778e-17
C10_22 6 66 8.69778e-17
R10_3 7 9 576
C10_31 7 66 9.6642e-17
C10_32 9 66 9.6642e-17
R9_1 15 13 15
R9_2 15 14 480
C9_21 15 66 8.69778e-17
C9_22 14 66 8.69778e-17
R9_3 12 15 576
C9_31 12 66 9.6642e-17
C9_32 15 66 9.6642e-17
R8_1 21 19 15
R8_2 21 20 480
C8_21 21 66 8.69778e-17
C8_22 20 66 8.69778e-17
R8_3 18 21 576
C8_31 18 66 9.6642e-17
C8_32 21 66 9.6642e-17
R7_1 27 25 15
R7_2 27 26 480
C7_21 27 66 8.69778e-17
C7_22 26 66 8.69778e-17
R7_3 24 27 576
C7_31 24 66 9.6642e-17
C7_32 27 66 9.6642e-17
R5_1 37 33 15
R5_2 35 33 15
R5_3 36 33 15
R5_4 33 34 15
R5_5 37 38 26
C5_51 37 66 6.42888e-17
C5_52 38 66 6.42888e-17
R5_6 36 37 13
C5_61 36 66 5.3574e-17
C5_62 37 66 5.3574e-17
R5_7 35 36 26
C5_71 35 66 6.42888e-17
C5_72 36 66 6.42888e-17
R5_8 34 35 26
C5_81 34 66 6.42888e-17
C5_82 35 66 6.42888e-17
R2_1 52 51 15
R2_2 62 59 15
R2_3 60 59 15
R2_4 63 59 15
R2_5 61 59 15
R2_6 49 48 15
R2_7 55 57 15
R2_8 55 58 912
C2_81 55 66 1.59459e-16
C2_82 58 66 1.59459e-16
R2_9 56 57 26
C2_91 56 66 6.42888e-17
C2_92 57 66 6.42888e-17
R2_10 49 50 13
C2_101 49 66 5.3574e-17
C2_102 50 66 5.3574e-17
R2_11 62 63 13
C2_111 62 66 5.3574e-17
C2_112 63 66 5.3574e-17
R2_12 60 62 26
C2_121 60 66 6.42888e-17
C2_122 62 66 6.42888e-17
R2_13 61 60 26
C2_131 61 66 6.42888e-17
C2_132 60 66 6.42888e-17
R2_14 47 61 65
C2_141 47 66 1.71437e-16
C2_142 61 66 1.71437e-16
R2_15 54 56 26
C2_151 54 66 6.42888e-17
C2_152 56 66 6.42888e-17
R2_16 53 54 13
C2_161 53 66 3.21444e-17
C2_162 54 66 3.21444e-17
R2_17 50 53 52
C2_171 50 66 1.28578e-16
C2_172 53 66 1.28578e-16
R2_18 47 50 26
C2_181 47 66 6.42888e-17
C2_182 50 66 6.42888e-17
R2_19 52 53 13
C2_191 52 66 5.3574e-17
C2_192 53 66 5.3574e-17
R1_1 73 71 15
R1_2 72 71 7.5
R1_3 68 67 15
R1_4 70 69 15
R1_5 66 70 26
C1_51 66 66 6.42888e-17
C1_52 70 66 6.42888e-17
R1_6 66 68 26
C1_61 66 66 6.42888e-17
C1_62 68 66 6.42888e-17
R1_7 72 73 26
C1_71 72 66 6.42888e-17
C1_72 73 66 6.42888e-17
R1_8 66 72 26
C1_81 66 66 6.42888e-17
C1_82 72 66 6.42888e-17
.ends o4_x2
