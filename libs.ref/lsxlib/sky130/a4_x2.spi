* Spice description of a4_x2
* Spice driver version 399543213
* Date ( dd/mm/yyyy hh:mm:ss ):  8/05/2026 at 14:22:52

* INTERF i0 i1 i2 i3 q vdd vss

.subckt a4_x2 7 33 12 2 50 46 54
* NET 2 = i3
* NET 7 = i0
* NET 12 = i2
* NET 33 = i1
* NET 46 = vdd
* NET 50 = q
* NET 54 = vss
Mtr_00010 23 8 37 46 sky130_fd_pr__pfet_01v8__model L=0.15U W=1.26U AS=0.3654P AD=0.3654P PS=3.1U PD=3.1U
Mtr_00009 51 20 37 46 sky130_fd_pr__pfet_01v8__model L=0.15U W=2.46U AS=0.7134P AD=0.7134P PS=5.5U PD=5.5U
Mtr_00008 42 3 25 46 sky130_fd_pr__pfet_01v8__model L=0.15U W=1.26U AS=0.3654P AD=0.3654P PS=3.1U PD=3.1U
Mtr_00007 25 13 41 46 sky130_fd_pr__pfet_01v8__model L=0.15U W=1.26U AS=0.3654P AD=0.3654P PS=3.1U PD=3.1U
Mtr_00006 41 34 23 46 sky130_fd_pr__pfet_01v8__model L=0.15U W=1.26U AS=0.3654P AD=0.3654P PS=3.1U PD=3.1U
Mtr_00005 55 6 60 54 sky130_fd_pr__nfet_01v8__model L=0.15U W=1.26U AS=0.3654P AD=0.3654P PS=3.1U PD=3.1U
Mtr_00004 60 32 63 54 sky130_fd_pr__nfet_01v8__model L=0.15U W=1.26U AS=0.3654P AD=0.3654P PS=3.1U PD=3.1U
Mtr_00003 66 1 17 54 sky130_fd_pr__nfet_01v8__model L=0.15U W=1.26U AS=0.3654P AD=0.3654P PS=3.1U PD=3.1U
Mtr_00002 63 11 66 54 sky130_fd_pr__nfet_01v8__model L=0.15U W=1.26U AS=0.3654P AD=0.3654P PS=3.1U PD=3.1U
Mtr_00001 55 16 49 54 sky130_fd_pr__nfet_01v8__model L=0.15U W=1.26U AS=0.3654P AD=0.3654P PS=3.1U PD=3.1U
R11_1 1 2 15
R11_2 3 2 15
R10_1 6 7 15
R10_2 8 7 15
R9_1 11 12 15
R9_2 13 12 15
R8_1 21 22 15
R8_2 19 17 15
R8_3 18 17 15
R8_4 26 25 15
R8_5 24 23 15
R8_6 29 25 15
R8_7 28 23 15
R8_8 24 28 13
C8_81 24 54 5.3574e-17
C8_82 28 54 5.3574e-17
R8_9 26 29 13
C8_91 26 54 5.3574e-17
C8_92 29 54 5.3574e-17
R8_10 26 27 26
C8_101 26 54 6.42888e-17
C8_102 27 54 6.42888e-17
R8_11 24 26 52
C8_111 24 54 1.28578e-16
C8_112 26 54 1.28578e-16
R8_12 22 27 78
C8_121 22 54 1.82152e-16
C8_122 27 54 1.82152e-16
R8_13 19 22 39
C8_131 19 54 9.64332e-17
C8_132 22 54 9.64332e-17
R8_14 18 19 26
C8_141 18 54 7.50036e-17
C8_142 19 54 7.50036e-17
R8_15 21 20 480
C8_151 21 54 8.69778e-17
C8_152 20 54 8.69778e-17
R8_16 16 21 480
C8_161 16 54 8.0535e-17
C8_162 21 54 8.0535e-17
R7_1 32 33 15
R7_2 34 33 15
R6_1 37 38 15
R6_2 43 37 15
R6_3 39 37 15
R6_4 40 37 15
R6_5 45 42 15
R6_6 44 41 15
R6_7 44 46 26
C6_71 44 54 6.42888e-17
C6_72 46 54 6.42888e-17
R6_8 45 46 26
C6_81 45 54 6.42888e-17
C6_82 46 54 6.42888e-17
R6_9 43 46 26
C6_91 43 54 6.42888e-17
C6_92 46 54 6.42888e-17
R6_10 40 43 13
C6_101 40 54 5.3574e-17
C6_102 43 54 5.3574e-17
R6_11 39 40 26
C6_111 39 54 6.42888e-17
C6_112 40 54 6.42888e-17
R6_12 38 39 26
C6_121 38 54 6.42888e-17
C6_122 39 54 6.42888e-17
R5_1 50 49 7.5
R5_2 50 51 3.75
R4_1 55 57 15
R4_2 55 56 15
R4_3 56 57 26
C4_31 56 54 7.50036e-17
C4_32 57 54 7.50036e-17
R4_4 54 56 26
C4_41 54 54 6.42888e-17
C4_42 56 54 6.42888e-17
.ends a4_x2
