* Spice description of noa3ao322_x1
* Spice driver version 1182018477
* Date ( dd/mm/yyyy hh:mm:ss ):  8/05/2026 at 14:22:51

* INTERF i0 i1 i2 i3 i4 i5 i6 nq nq vdd vss

.subckt noa3ao322_x1 42 60 54 9 20 14 49 90 91 5 69
* NET 5 = vdd
* NET 9 = i3
* NET 14 = i5
* NET 20 = i4
* NET 42 = i0
* NET 49 = i6
* NET 54 = i2
* NET 60 = i1
* NET 69 = vss
* NET 90 = nq
* NET 91 = nq
Mtr_00014 1 45 27 5 sky130_fd_pr__pfet_01v8__model L=0.15U W=1.5U AS=0.435P AD=0.435P PS=3.58U PD=3.58U
Mtr_00013 27 63 2 5 sky130_fd_pr__pfet_01v8__model L=0.15U W=1.5U AS=0.435P AD=0.435P PS=3.58U PD=3.58U
Mtr_00012 2 57 28 5 sky130_fd_pr__pfet_01v8__model L=0.15U W=1.5U AS=0.435P AD=0.435P PS=3.58U PD=3.58U
Mtr_00011 28 51 92 5 sky130_fd_pr__pfet_01v8__model L=0.15U W=1.5U AS=0.435P AD=0.435P PS=3.58U PD=3.58U
Mtr_00010 39 10 92 5 sky130_fd_pr__pfet_01v8__model L=0.15U W=2.46U AS=0.7134P AD=0.7134P PS=5.5U PD=5.5U
Mtr_00009 36 22 39 5 sky130_fd_pr__pfet_01v8__model L=0.15U W=2.46U AS=0.7134P AD=0.7134P PS=5.5U PD=5.5U
Mtr_00008 36 16 26 5 sky130_fd_pr__pfet_01v8__model L=0.15U W=2.46U AS=0.7134P AD=0.7134P PS=5.5U PD=5.5U
Mtr_00007 83 21 72 69 sky130_fd_pr__nfet_01v8__model L=0.15U W=0.54U AS=0.1566P AD=0.1566P PS=1.66U PD=1.66U
Mtr_00006 72 8 81 69 sky130_fd_pr__nfet_01v8__model L=0.15U W=0.54U AS=0.1566P AD=0.1566P PS=1.66U PD=1.66U
Mtr_00005 81 48 89 69 sky130_fd_pr__nfet_01v8__model L=0.15U W=0.54U AS=0.1566P AD=0.1566P PS=1.66U PD=1.66U
Mtr_00004 89 55 78 69 sky130_fd_pr__nfet_01v8__model L=0.15U W=1.14U AS=0.3306P AD=0.3306P PS=2.86U PD=2.86U
Mtr_00003 78 61 66 69 sky130_fd_pr__nfet_01v8__model L=0.15U W=1.14U AS=0.3306P AD=0.3306P PS=2.86U PD=2.86U
Mtr_00002 66 43 70 69 sky130_fd_pr__nfet_01v8__model L=0.15U W=1.14U AS=0.3306P AD=0.3306P PS=2.86U PD=2.86U
Mtr_00001 74 15 83 69 sky130_fd_pr__nfet_01v8__model L=0.15U W=0.54U AS=0.1566P AD=0.1566P PS=1.66U PD=1.66U
R16_1 3 1 15
R16_2 4 2 15
R16_3 4 5 26
C16_31 4 69 6.42888e-17
C16_32 5 69 6.42888e-17
R16_4 3 5 26
C16_41 3 69 6.42888e-17
C16_42 5 69 6.42888e-17
R15_1 11 9 15
R15_2 11 10 528
C15_21 11 69 9.34206e-17
C15_22 10 69 9.34206e-17
R15_3 8 11 528
C15_31 8 69 9.34206e-17
C15_32 11 69 9.34206e-17
R14_1 17 14 15
R14_2 17 16 528
C14_21 17 69 9.34206e-17
C14_22 16 69 9.34206e-17
R14_3 15 17 528
C14_31 15 69 9.34206e-17
C14_32 17 69 9.34206e-17
R13_1 23 20 15
R13_2 23 22 528
C13_21 23 69 9.34206e-17
C13_22 22 69 9.34206e-17
R13_3 21 23 528
C13_31 21 69 9.34206e-17
C13_32 23 69 9.34206e-17
R12_1 33 26 15
R12_2 32 28 15
R12_3 31 27 15
R12_4 29 31 13
C12_41 29 69 5.3574e-17
C12_42 31 69 5.3574e-17
R12_5 29 30 52
C12_51 29 69 1.28578e-16
C12_52 30 69 1.28578e-16
R12_6 30 32 13
C12_61 30 69 5.3574e-17
C12_62 32 69 5.3574e-17
R12_7 32 33 104
C12_71 32 69 2.57155e-16
C12_72 33 69 2.57155e-16
R9_1 44 42 15
R9_2 44 45 672
C9_21 44 69 1.19192e-16
C9_22 45 69 1.19192e-16
R9_3 43 44 432
C9_31 43 69 7.73136e-17
C9_32 44 69 7.73136e-17
R8_1 50 49 15
R8_2 50 51 672
C8_21 50 69 1.19192e-16
C8_22 51 69 1.19192e-16
R8_3 48 50 528
C8_31 48 69 9.34206e-17
C8_32 50 69 9.34206e-17
R7_1 56 54 15
R7_2 56 57 672
C7_21 56 69 1.19192e-16
C7_22 57 69 1.19192e-16
R7_3 55 56 432
C7_31 55 69 7.73136e-17
C7_32 56 69 7.73136e-17
R6_1 62 60 15
R6_2 62 63 672
C6_21 62 69 1.19192e-16
C6_22 63 69 1.19192e-16
R6_3 61 62 432
C6_31 61 69 7.73136e-17
C6_32 62 69 7.73136e-17
R4_1 71 70 15
R4_2 75 74 15
R4_3 73 72 15
R4_4 69 73 26
C4_41 69 69 6.42888e-17
C4_42 73 69 6.42888e-17
R4_5 69 75 26
C4_51 69 69 6.42888e-17
C4_52 75 69 6.42888e-17
R4_6 69 71 26
C4_61 69 69 6.42888e-17
C4_62 71 69 6.42888e-17
R2_1 82 81 15
R2_2 84 83 7.5
R2_3 84 86 13
C2_31 84 69 5.3574e-17
C2_32 86 69 5.3574e-17
R2_4 85 86 52
C2_41 85 69 1.28578e-16
C2_42 86 69 1.28578e-16
R2_5 82 85 13
C2_51 82 69 5.3574e-17
C2_52 85 69 5.3574e-17
R1_1 90 89 7.5
R1_2 91 92 5
R1_3 90 91 26
C1_31 90 69 6.42888e-17
C1_32 91 69 6.42888e-17
.ends noa3ao322_x1
