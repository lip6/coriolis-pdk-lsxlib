* Spice description of an12_x1
* Spice driver version -360416339
* Date ( dd/mm/yyyy hh:mm:ss ):  8/05/2026 at 14:22:51

* INTERF i0 i1 q q vdd vss

.subckt an12_x1 2 7 24 22 19 39
* NET 2 = i0
* NET 7 = i1
* NET 19 = vdd
* NET 24 = q
* NET 22 = q
* NET 39 = vss
Mtr_00006 34 10 16 19 sky130_fd_pr__pfet_01v8__model L=0.15U W=1.26U AS=0.3654P AD=0.3654P PS=3.1U PD=3.1U
Mtr_00005 13 4 25 19 sky130_fd_pr__pfet_01v8__model L=0.15U W=2.46U AS=0.7134P AD=0.7134P PS=5.5U PD=5.5U
Mtr_00004 16 31 13 19 sky130_fd_pr__pfet_01v8__model L=0.15U W=2.46U AS=0.7134P AD=0.7134P PS=5.5U PD=5.5U
Mtr_00003 42 8 29 39 sky130_fd_pr__nfet_01v8__model L=0.15U W=0.66U AS=0.1914P AD=0.1914P PS=1.9U PD=1.9U
Mtr_00002 23 28 42 39 sky130_fd_pr__nfet_01v8__model L=0.15U W=0.66U AS=0.1914P AD=0.1914P PS=1.9U PD=1.9U
Mtr_00001 40 1 23 39 sky130_fd_pr__nfet_01v8__model L=0.15U W=0.66U AS=0.1914P AD=0.1914P PS=1.9U PD=1.9U
R7_1 3 2 15
R7_2 3 4 672
C7_21 3 39 1.12749e-16
C7_22 4 39 1.12749e-16
R7_3 1 3 384
C7_31 1 39 7.08708e-17
C7_32 3 39 7.08708e-17
R6_1 9 7 15
R6_2 8 7 15
R6_3 9 10 672
C6_31 9 39 1.12749e-16
C6_32 10 39 1.12749e-16
R4_1 17 16 15
R4_2 18 16 15
R4_3 18 19 26
C4_31 18 39 6.42888e-17
C4_32 19 39 6.42888e-17
R4_4 17 18 13
C4_41 17 39 4.28592e-17
C4_42 18 39 4.28592e-17
R3_1 24 23 15
R3_2 22 25 3.75
R3_3 22 24 26
C3_31 22 39 6.42888e-17
C3_32 24 39 6.42888e-17
R2_1 30 29 15
R2_2 35 34 15
R2_3 36 34 15
R2_4 32 33 15
R2_5 32 31 672
C2_51 32 39 1.12749e-16
C2_52 31 39 1.12749e-16
R2_6 28 32 384
C2_61 28 39 7.08708e-17
C2_62 32 39 7.08708e-17
R2_7 35 36 26
C2_71 35 39 6.42888e-17
C2_72 36 39 6.42888e-17
R2_8 33 35 91
C2_81 33 39 2.14296e-16
C2_82 35 39 2.14296e-16
R2_9 30 33 52
C2_91 30 39 1.28578e-16
C2_92 33 39 1.28578e-16
R1_1 43 42 7.5
R1_2 41 40 15
R1_3 39 41 26
C1_31 39 39 6.42888e-17
C1_32 41 39 6.42888e-17
R1_4 39 43 26
C1_41 39 39 6.42888e-17
C1_42 43 39 6.42888e-17
.ends an12_x1
