* Spice description of xr2_x4
* Spice driver version -751023187
* Date ( dd/mm/yyyy hh:mm:ss ):  8/05/2026 at 14:23:17

* INTERF i0 i1 q vdd vss

.subckt xr2_x4 6 32 2 53 88
* NET 2 = q
* NET 6 = i0
* NET 32 = i1
* NET 53 = vdd
* NET 88 = vss
Mtr_00016 3 74 41 53 sky130_fd_pr__pfet_01v8__model L=0.15U W=2.46U AS=0.7134P AD=0.7134P PS=5.5U PD=5.5U
Mtr_00015 43 77 3 53 sky130_fd_pr__pfet_01v8__model L=0.15U W=2.46U AS=0.7134P AD=0.7134P PS=5.5U PD=5.5U
Mtr_00014 56 11 39 53 sky130_fd_pr__pfet_01v8__model L=0.15U W=2.34U AS=0.6786P AD=0.6786P PS=5.26U PD=5.26U
Mtr_00013 25 36 40 53 sky130_fd_pr__pfet_01v8__model L=0.15U W=1.26U AS=0.3654P AD=0.3654P PS=3.1U PD=3.1U
Mtr_00012 39 12 106 53 sky130_fd_pr__pfet_01v8__model L=0.15U W=1.26U AS=0.3654P AD=0.3654P PS=3.1U PD=3.1U
Mtr_00011 40 24 57 53 sky130_fd_pr__pfet_01v8__model L=0.15U W=2.34U AS=0.6786P AD=0.6786P PS=5.26U PD=5.26U
Mtr_00010 57 107 78 53 sky130_fd_pr__pfet_01v8__model L=0.15U W=2.34U AS=0.6786P AD=0.6786P PS=5.26U PD=5.26U
Mtr_00009 78 33 56 53 sky130_fd_pr__pfet_01v8__model L=0.15U W=2.34U AS=0.6786P AD=0.6786P PS=5.26U PD=5.26U
Mtr_00008 91 30 16 88 sky130_fd_pr__nfet_01v8__model L=0.15U W=0.66U AS=0.1914P AD=0.1914P PS=1.9U PD=1.9U
Mtr_00007 93 71 1 88 sky130_fd_pr__nfet_01v8__model L=0.15U W=1.26U AS=0.3654P AD=0.3654P PS=3.1U PD=3.1U
Mtr_00006 1 73 95 88 sky130_fd_pr__nfet_01v8__model L=0.15U W=1.26U AS=0.3654P AD=0.3654P PS=3.1U PD=3.1U
Mtr_00005 112 31 91 88 sky130_fd_pr__nfet_01v8__model L=0.15U W=1.14U AS=0.3306P AD=0.3306P PS=2.86U PD=2.86U
Mtr_00004 67 102 112 88 sky130_fd_pr__nfet_01v8__model L=0.15U W=1.14U AS=0.3306P AD=0.3306P PS=2.86U PD=2.86U
Mtr_00003 85 15 67 88 sky130_fd_pr__nfet_01v8__model L=0.15U W=1.14U AS=0.3306P AD=0.3306P PS=2.86U PD=2.86U
Mtr_00002 89 8 85 88 sky130_fd_pr__nfet_01v8__model L=0.15U W=1.14U AS=0.3306P AD=0.3306P PS=2.86U PD=2.86U
Mtr_00001 100 7 89 88 sky130_fd_pr__nfet_01v8__model L=0.15U W=0.66U AS=0.1914P AD=0.1914P PS=1.9U PD=1.9U
R11_1 2 1 7.5
R11_2 2 3 3.75
R10_1 9 6 15
R10_2 10 6 15
R10_3 7 10 336
C10_31 7 88 5.71799e-17
C10_32 10 88 5.71799e-17
R10_4 10 8 144
C10_41 10 88 2.9798e-17
C10_42 8 88 2.9798e-17
R10_5 9 12 624
C10_51 9 88 1.05501e-16
C10_52 12 88 1.05501e-16
R10_6 9 11 144
C10_61 9 88 2.9798e-17
C10_62 11 88 2.9798e-17
R9_1 15 17 15
R9_2 20 19 15
R9_3 23 22 15
R9_4 27 25 15
R9_5 26 25 15
R9_6 21 16 15
R9_7 26 27 26
C9_71 26 88 6.42888e-17
C9_72 27 88 6.42888e-17
R9_8 22 26 78
C9_81 22 88 1.92866e-16
C9_82 26 88 1.92866e-16
R9_9 21 22 13
C9_91 21 88 4.28592e-17
C9_92 22 88 4.28592e-17
R9_10 20 23 336
C9_101 20 88 6.36227e-17
C9_102 23 88 6.36227e-17
R9_11 20 24 624
C9_111 20 88 1.08722e-16
C9_112 24 88 1.08722e-16
R9_12 18 19 39
C9_121 18 88 9.64332e-17
C9_122 19 88 9.64332e-17
R9_13 17 18 13
C9_131 17 88 3.21444e-17
C9_132 18 88 3.21444e-17
R8_1 33 34 15
R8_2 35 32 15
R8_3 30 32 15
R8_4 31 30 144
C8_41 31 88 2.9798e-17
C8_42 30 88 2.9798e-17
R8_5 35 36 624
C8_51 35 88 1.05501e-16
C8_52 36 88 1.05501e-16
R8_6 34 32 65
C8_61 34 88 1.50007e-16
C8_62 32 88 1.50007e-16
R7_1 49 39 15
R7_2 50 40 15
R7_3 52 43 15
R7_4 48 43 15
R7_5 46 43 15
R7_6 44 43 15
R7_7 45 41 15
R7_8 47 41 15
R7_9 51 41 15
R7_10 42 41 15
R7_11 51 53 26
C7_111 51 88 6.42888e-17
C7_112 53 88 6.42888e-17
R7_12 47 51 13
C7_121 47 88 5.3574e-17
C7_122 51 88 5.3574e-17
R7_13 45 47 26
C7_131 45 88 6.42888e-17
C7_132 47 88 6.42888e-17
R7_14 42 45 26
C7_141 42 88 6.42888e-17
C7_142 45 88 6.42888e-17
R7_15 52 53 26
C7_151 52 88 6.42888e-17
C7_152 53 88 6.42888e-17
R7_16 48 52 13
C7_161 48 88 5.3574e-17
C7_162 52 88 5.3574e-17
R7_17 46 48 26
C7_171 46 88 6.42888e-17
C7_172 48 88 6.42888e-17
R7_18 44 46 26
C7_181 44 88 6.42888e-17
C7_182 46 88 6.42888e-17
R7_19 50 53 26
C7_191 50 88 6.42888e-17
C7_192 53 88 6.42888e-17
R7_20 49 53 26
C7_201 49 88 6.42888e-17
C7_202 53 88 6.42888e-17
R6_1 57 62 15
R6_2 57 58 15
R6_3 57 60 15
R6_4 57 64 15
R6_5 63 56 15
R6_6 61 56 15
R6_7 59 56 15
R6_8 61 63 13
C6_81 61 88 5.3574e-17
C6_82 63 88 5.3574e-17
R6_9 59 61 13
C6_91 59 88 5.3574e-17
C6_92 61 88 5.3574e-17
R6_10 63 64 52
C6_101 63 88 1.28578e-16
C6_102 64 88 1.28578e-16
R6_11 62 64 13
C6_111 62 88 5.3574e-17
C6_112 64 88 5.3574e-17
R6_12 60 62 13
C6_121 60 88 5.3574e-17
C6_122 62 88 5.3574e-17
R6_13 58 60 13
C6_131 58 88 5.3574e-17
C6_132 60 88 5.3574e-17
R5_1 68 67 15
R5_2 69 67 15
R5_3 76 75 15
R5_4 80 78 15
R5_5 81 78 15
R5_6 82 78 15
R5_7 76 74 576
C5_71 76 88 9.98634e-17
C5_72 74 88 9.98634e-17
R5_8 71 76 384
C5_81 71 88 6.76494e-17
C5_82 76 88 6.76494e-17
R5_9 76 77 576
C5_91 76 88 9.98634e-17
C5_92 77 88 9.98634e-17
R5_10 73 76 384
C5_101 73 88 6.76494e-17
C5_102 76 88 6.76494e-17
R5_11 82 81 13
C5_111 82 88 5.3574e-17
C5_112 81 88 5.3574e-17
R5_12 80 82 13
C5_121 80 88 5.3574e-17
C5_122 82 88 5.3574e-17
R5_13 79 80 26
C5_131 79 88 6.42888e-17
C5_132 80 88 6.42888e-17
R5_14 70 79 78
C5_141 70 88 1.92866e-16
C5_142 79 88 1.92866e-16
R5_15 72 75 39
C5_151 72 88 9.64332e-17
C5_152 75 88 9.64332e-17
R5_16 69 72 104
C5_161 69 88 2.4644e-16
C5_162 72 88 2.4644e-16
R5_17 70 69 26
C5_171 70 88 6.42888e-17
C5_172 69 88 6.42888e-17
R5_18 68 69 13
C5_181 68 88 5.3574e-17
C5_182 69 88 5.3574e-17
R3_1 90 89 15
R3_2 94 93 15
R3_3 92 91 15
R3_4 96 95 15
R3_5 97 95 15
R3_6 96 97 13
C3_61 96 88 5.3574e-17
C3_62 97 88 5.3574e-17
R3_7 88 96 26
C3_71 88 88 6.42888e-17
C3_72 96 88 6.42888e-17
R3_8 88 92 26
C3_81 88 88 6.42888e-17
C3_82 92 88 6.42888e-17
R3_9 88 94 26
C3_91 88 88 6.42888e-17
C3_92 94 88 6.42888e-17
R3_10 88 90 26
C3_101 88 88 6.42888e-17
C3_102 90 88 6.42888e-17
R2_1 101 100 15
R2_2 108 106 15
R2_3 109 106 15
R2_4 104 103 15
R2_5 105 107 576
C2_51 105 88 1.03085e-16
C2_52 107 88 1.03085e-16
R2_6 102 105 384
C2_61 102 88 7.08708e-17
C2_62 105 88 7.08708e-17
R2_7 104 105 768
C2_71 104 88 1.35299e-16
C2_72 105 88 1.35299e-16
R2_8 108 109 26
C2_81 108 88 6.42888e-17
C2_82 109 88 6.42888e-17
R2_9 103 108 78
C2_91 103 88 1.92866e-16
C2_92 108 88 1.92866e-16
R2_10 101 103 65
C2_101 101 88 1.50007e-16
C2_102 103 88 1.50007e-16
.ends xr2_x4
