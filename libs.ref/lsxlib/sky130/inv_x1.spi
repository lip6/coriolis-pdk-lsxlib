* Spice description of inv_x1
* Spice driver version 1958644653
* Date ( dd/mm/yyyy hh:mm:ss ):  8/05/2026 at 13:38:27

* INTERF i nq vdd vss

.subckt inv_x1 6 13 3 17
* NET 3 = vdd
* NET 6 = i
* NET 13 = nq
* NET 17 = vss
Mtr_00002 14 9 1 3 sky130_fd_pr__pfet_01v8__model L=0.15U W=1.26U AS=0.3654P AD=0.3654P PS=3.1U PD=3.1U
Mtr_00001 18 7 12 17 sky130_fd_pr__nfet_01v8__model L=0.15U W=0.66U AS=0.1914P AD=0.1914P PS=1.9U PD=1.9U
R4_1 1 2 15
R4_2 2 3 26
C4_21 2 17 6.42888e-17
C4_22 3 17 6.42888e-17
R3_1 8 6 15
R3_2 8 9 768
C3_21 8 17 1.32077e-16
C3_22 9 17 1.32077e-16
R3_3 7 8 480
C3_31 7 17 8.37564e-17
C3_32 8 17 8.37564e-17
R2_1 12 13 15
R2_2 13 14 7.5
R1_1 18 19 15
R1_2 17 19 26
C1_21 17 17 6.42888e-17
C1_22 19 17 6.42888e-17
.ends inv_x1
