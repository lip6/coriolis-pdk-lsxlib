* Spice description of nmx2_x4
* Spice driver version 1867959213
* Date ( dd/mm/yyyy hh:mm:ss ):  8/05/2026 at 14:22:51

* INTERF cmd i0 i1 nq vdd vss

.subckt nmx2_x4 59 40 49 36 17 66
* NET 17 = vdd
* NET 36 = nq
* NET 40 = i0
* NET 49 = i1
* NET 59 = cmd
* NET 66 = vss
Mtr_00016 8 105 30 17 sky130_fd_pr__pfet_01v8__model L=0.15U W=1.26U AS=0.3654P AD=0.3654P PS=3.1U PD=3.1U
Mtr_00015 37 27 8 17 sky130_fd_pr__pfet_01v8__model L=0.15U W=2.46U AS=0.7134P AD=0.7134P PS=5.5U PD=5.5U
Mtr_00014 7 26 37 17 sky130_fd_pr__pfet_01v8__model L=0.15U W=2.46U AS=0.7134P AD=0.7134P PS=5.5U PD=5.5U
Mtr_00013 1 52 7 17 sky130_fd_pr__pfet_01v8__model L=0.15U W=1.26U AS=0.3654P AD=0.3654P PS=3.1U PD=3.1U
Mtr_00012 86 62 11 17 sky130_fd_pr__pfet_01v8__model L=0.15U W=1.02U AS=0.2958P AD=0.2958P PS=2.62U PD=2.62U
Mtr_00011 11 46 4 17 sky130_fd_pr__pfet_01v8__model L=0.15U W=1.26U AS=0.3654P AD=0.3654P PS=3.1U PD=3.1U
Mtr_00010 4 63 103 17 sky130_fd_pr__pfet_01v8__model L=0.15U W=1.26U AS=0.3654P AD=0.3654P PS=3.1U PD=3.1U
Mtr_00009 103 84 1 17 sky130_fd_pr__pfet_01v8__model L=0.15U W=1.26U AS=0.3654P AD=0.3654P PS=3.1U PD=3.1U
Mtr_00008 22 98 71 66 sky130_fd_pr__nfet_01v8__model L=0.15U W=0.66U AS=0.1914P AD=0.1914P PS=1.9U PD=1.9U
Mtr_00007 71 21 35 66 sky130_fd_pr__nfet_01v8__model L=0.15U W=1.26U AS=0.3654P AD=0.3654P PS=3.1U PD=3.1U
Mtr_00006 35 20 69 66 sky130_fd_pr__nfet_01v8__model L=0.15U W=1.26U AS=0.3654P AD=0.3654P PS=3.1U PD=3.1U
Mtr_00005 69 50 109 66 sky130_fd_pr__nfet_01v8__model L=0.15U W=0.66U AS=0.1914P AD=0.1914P PS=1.9U PD=1.9U
Mtr_00004 67 55 76 66 sky130_fd_pr__nfet_01v8__model L=0.15U W=0.54U AS=0.1566P AD=0.1566P PS=1.66U PD=1.66U
Mtr_00003 109 56 94 66 sky130_fd_pr__nfet_01v8__model L=0.15U W=0.66U AS=0.1914P AD=0.1914P PS=1.9U PD=1.9U
Mtr_00002 94 80 112 66 sky130_fd_pr__nfet_01v8__model L=0.15U W=0.66U AS=0.1914P AD=0.1914P PS=1.9U PD=1.9U
Mtr_00001 112 43 67 66 sky130_fd_pr__nfet_01v8__model L=0.15U W=0.66U AS=0.1914P AD=0.1914P PS=1.9U PD=1.9U
R11_1 13 7 15
R11_2 15 7 15
R11_3 16 8 15
R11_4 10 8 15
R11_5 12 8 15
R11_6 9 8 15
R11_7 14 11 15
R11_8 14 17 26
C11_81 14 66 6.42888e-17
C11_82 17 66 6.42888e-17
R11_9 16 17 26
C11_91 16 66 6.42888e-17
C11_92 17 66 6.42888e-17
R11_10 12 16 26
C11_101 12 66 6.42888e-17
C11_102 16 66 6.42888e-17
R11_11 10 12 26
C11_111 10 66 6.42888e-17
C11_112 12 66 6.42888e-17
R11_12 9 10 13
C11_121 9 66 5.3574e-17
C11_122 10 66 5.3574e-17
R11_13 15 17 26
C11_131 15 66 6.42888e-17
C11_132 17 66 6.42888e-17
R11_14 13 15 13
C11_141 13 66 5.3574e-17
C11_142 15 66 5.3574e-17
R10_1 23 22 15
R10_2 32 30 15
R10_3 31 30 15
R10_4 29 28 15
R10_5 25 24 15
R10_6 21 25 288
C10_61 21 66 5.15424e-17
C10_62 25 66 5.15424e-17
R10_7 20 21 192
C10_71 20 66 3.86568e-17
C10_72 21 66 3.86568e-17
R10_8 27 29 288
C10_81 27 66 5.15424e-17
C10_82 29 66 5.15424e-17
R10_9 26 27 192
C10_91 26 66 3.86568e-17
C10_92 27 66 3.86568e-17
R10_10 31 32 26
C10_101 31 66 7.50036e-17
C10_102 32 66 7.50036e-17
R10_11 28 31 52
C10_111 28 66 1.39292e-16
C10_112 31 66 1.39292e-16
R10_12 24 28 26
C10_121 24 66 8.57184e-17
C10_122 28 66 8.57184e-17
R10_13 23 24 39
C10_131 23 66 1.07148e-16
C10_132 24 66 1.07148e-16
R9_1 36 35 7.5
R9_2 36 37 3.75
R8_1 41 40 15
R8_2 44 40 15
R8_3 45 46 288
C8_31 45 66 5.47638e-17
C8_32 46 66 5.47638e-17
R8_4 44 45 96
C8_41 44 66 1.93284e-17
C8_42 45 66 1.93284e-17
R8_5 42 43 48
C8_51 42 66 1.28856e-17
C8_52 43 66 1.28856e-17
R8_6 42 41 192
C8_61 42 66 3.2214e-17
C8_62 41 66 3.2214e-17
R7_1 51 49 15
R7_2 51 52 480
C7_21 51 66 8.0535e-17
C7_22 52 66 8.0535e-17
R7_3 50 51 768
C7_31 50 66 1.35299e-16
C7_32 51 66 1.35299e-16
R6_1 60 59 15
R6_2 57 56 48
C6_21 57 66 1.28856e-17
C6_22 56 66 1.28856e-17
R6_3 57 61 384
C6_31 57 66 6.4428e-17
C6_32 61 66 6.4428e-17
R6_4 58 62 768
C6_41 58 66 1.29661e-16
C6_42 62 66 1.29661e-16
R6_5 55 58 528
C6_51 55 66 9.10046e-17
C6_52 58 66 9.10046e-17
R6_6 60 61 192
C6_61 60 66 3.78515e-17
C6_62 61 66 3.78515e-17
R6_7 58 60 384
C6_71 58 66 6.52334e-17
C6_72 60 66 6.52334e-17
R6_8 60 63 720
C6_81 60 66 1.25635e-16
C6_82 63 66 1.25635e-16
R5_1 68 67 15
R5_2 73 71 15
R5_3 72 71 15
R5_4 70 69 15
R5_5 66 70 26
C5_51 66 66 6.42888e-17
C5_52 70 66 6.42888e-17
R5_6 72 73 26
C5_61 72 66 7.50036e-17
C5_62 73 66 7.50036e-17
R5_7 66 72 26
C5_71 66 66 6.42888e-17
C5_72 72 66 6.42888e-17
R5_8 66 68 26
C5_81 66 66 6.42888e-17
C5_82 68 66 6.42888e-17
R4_1 77 76 15
R4_2 89 86 15
R4_3 87 86 15
R4_4 82 81 15
R4_5 84 85 15
R4_6 80 83 336
C4_61 80 66 5.79852e-17
C4_62 83 66 5.79852e-17
R4_7 82 83 48
C4_71 82 66 2.01449e-17
C4_72 83 66 2.01449e-17
R4_8 85 91 52
C4_81 85 66 1.17863e-16
C4_82 91 66 1.17863e-16
R4_9 90 91 52
C4_91 90 66 1.17863e-16
C4_92 91 66 1.17863e-16
R4_10 79 81 13
C4_101 79 66 5.3574e-17
C4_102 81 66 5.3574e-17
R4_11 88 90 13
C4_111 88 66 5.3574e-17
C4_112 90 66 5.3574e-17
R4_12 78 79 52
C4_121 78 66 1.17863e-16
C4_122 79 66 1.17863e-16
R4_13 87 88 52
C4_131 87 66 1.17863e-16
C4_132 88 66 1.17863e-16
R4_14 87 89 13
C4_141 87 66 5.3574e-17
C4_142 89 66 5.3574e-17
R4_15 78 87 130
C4_151 78 66 3.00014e-16
C4_152 87 66 3.00014e-16
R4_16 77 78 13
C4_161 77 66 5.3574e-17
C4_162 78 66 5.3574e-17
R3_1 95 94 15
R3_2 104 103 15
R3_3 101 100 15
R3_4 98 99 192
C3_41 98 66 3.86568e-17
C3_42 99 66 3.86568e-17
R3_5 105 106 192
C3_51 105 66 3.86568e-17
C3_52 106 66 3.86568e-17
R3_6 102 106 528
C3_61 102 66 9.01992e-17
C3_62 106 66 9.01992e-17
R3_7 99 102 336
C3_71 99 66 5.79852e-17
C3_72 102 66 5.79852e-17
R3_8 101 102 768
C3_81 101 66 1.28856e-16
C3_82 102 66 1.28856e-16
R3_9 97 100 39
C3_91 97 66 9.64332e-17
C3_92 100 66 9.64332e-17
R3_10 96 97 52
C3_101 96 66 1.33935e-16
C3_102 97 66 1.33935e-16
R3_11 96 104 130
C3_111 96 66 3.00014e-16
C3_112 104 66 3.00014e-16
R3_12 95 96 13
C3_121 95 66 5.3574e-17
C3_122 96 66 5.3574e-17
.ends nmx2_x4
