* Spice description of a3_x4
* Spice driver version 576097197
* Date ( dd/mm/yyyy hh:mm:ss ):  8/05/2026 at 14:22:52

* INTERF i0 i1 i2 q q q vdd vss

.subckt a3_x4 31 9 2 62 63 65 44 53
* NET 2 = i2
* NET 9 = i1
* NET 31 = i0
* NET 44 = vdd
* NET 53 = vss
* NET 62 = q
* NET 63 = q
* NET 65 = q
Mtr_00010 41 11 23 44 sky130_fd_pr__pfet_01v8__model L=0.15U W=1.26U AS=0.3654P AD=0.3654P PS=3.1U PD=3.1U
Mtr_00009 25 5 41 44 sky130_fd_pr__pfet_01v8__model L=0.15U W=1.26U AS=0.3654P AD=0.3654P PS=3.1U PD=3.1U
Mtr_00008 23 34 38 44 sky130_fd_pr__pfet_01v8__model L=0.15U W=1.26U AS=0.3654P AD=0.3654P PS=3.1U PD=3.1U
Mtr_00007 37 19 64 44 sky130_fd_pr__pfet_01v8__model L=0.15U W=2.46U AS=0.7134P AD=0.7134P PS=5.5U PD=5.5U
Mtr_00006 64 19 38 44 sky130_fd_pr__pfet_01v8__model L=0.15U W=2.46U AS=0.7134P AD=0.7134P PS=5.5U PD=5.5U
Mtr_00005 61 14 54 53 sky130_fd_pr__nfet_01v8__model L=0.15U W=1.26U AS=0.3654P AD=0.3654P PS=3.1U PD=3.1U
Mtr_00004 47 1 17 53 sky130_fd_pr__nfet_01v8__model L=0.15U W=1.26U AS=0.3654P AD=0.3654P PS=3.1U PD=3.1U
Mtr_00003 50 8 47 53 sky130_fd_pr__nfet_01v8__model L=0.15U W=1.26U AS=0.3654P AD=0.3654P PS=3.1U PD=3.1U
Mtr_00002 55 32 50 53 sky130_fd_pr__nfet_01v8__model L=0.15U W=1.26U AS=0.3654P AD=0.3654P PS=3.1U PD=3.1U
Mtr_00001 55 15 61 53 sky130_fd_pr__nfet_01v8__model L=0.15U W=1.26U AS=0.3654P AD=0.3654P PS=3.1U PD=3.1U
R9_1 3 2 15
R9_2 4 5 624
C9_21 4 53 1.06306e-16
C9_22 5 53 1.06306e-16
R9_3 3 4 144
C9_31 3 53 2.57712e-17
C9_32 4 53 2.57712e-17
R9_4 1 3 384
C9_41 1 53 6.52334e-17
C9_42 3 53 6.52334e-17
R8_1 10 9 15
R8_2 10 11 768
C8_21 10 53 1.32077e-16
C8_22 11 53 1.32077e-16
R8_3 8 10 384
C8_31 8 53 6.76494e-17
C8_32 10 53 6.76494e-17
R7_1 19 20 15
R7_2 24 23 15
R7_3 27 23 15
R7_4 26 25 15
R7_5 18 17 15
R7_6 28 25 15
R7_7 26 28 13
C7_71 26 53 5.3574e-17
C7_72 28 53 5.3574e-17
R7_8 16 18 52
C7_81 16 53 1.17863e-16
C7_82 18 53 1.17863e-16
R7_9 24 26 52
C7_91 24 53 1.2322e-16
C7_92 26 53 1.2322e-16
R7_10 24 27 13
C7_101 24 53 5.3574e-17
C7_102 27 53 5.3574e-17
R7_11 22 24 52
C7_111 22 53 1.39292e-16
C7_112 24 53 1.39292e-16
R7_12 16 22 91
C7_121 16 53 2.14296e-16
C7_122 22 53 2.14296e-16
R7_13 21 22 52
C7_131 21 53 1.28578e-16
C7_132 22 53 1.28578e-16
R7_14 20 21 13
C7_141 20 53 3.21444e-17
C7_142 21 53 3.21444e-17
R7_15 14 19 912
C7_151 14 53 1.59459e-16
C7_152 19 53 1.59459e-16
R7_16 15 19 912
C7_161 15 53 1.59459e-16
C7_162 19 53 1.59459e-16
R6_1 33 31 15
R6_2 33 34 768
C6_21 33 53 1.29661e-16
C6_22 34 53 1.29661e-16
R6_3 32 33 384
C6_31 32 53 6.76494e-17
C6_32 33 53 6.76494e-17
R5_1 39 38 15
R5_2 40 37 15
R5_3 42 37 15
R5_4 43 41 15
R5_5 43 44 26
C5_51 43 53 6.42888e-17
C5_52 44 53 6.42888e-17
R5_6 42 44 26
C5_61 42 53 6.42888e-17
C5_62 44 53 6.42888e-17
R5_7 40 42 13
C5_71 40 53 4.28592e-17
C5_72 42 53 4.28592e-17
R5_8 39 44 78
C5_81 39 53 2.03581e-16
C5_82 44 53 2.03581e-16
R2_1 56 54 15
R2_2 58 54 15
R2_3 57 55 15
R2_4 53 57 26
C2_41 53 53 6.42888e-17
C2_42 57 53 6.42888e-17
R2_5 56 58 26
C2_51 56 53 7.50036e-17
C2_52 58 53 7.50036e-17
R2_6 53 56 26
C2_61 53 53 6.42888e-17
C2_62 56 53 6.42888e-17
R1_1 62 61 7.5
R1_2 65 64 3.75
R1_3 63 65 26
C1_31 63 53 6.42888e-17
C1_32 65 53 6.42888e-17
R1_4 63 62 26
C1_41 63 53 6.42888e-17
C1_42 62 53 6.42888e-17
.ends a3_x4
