* Spice description of o2_x2
* Spice driver version -2012525651
* Date ( dd/mm/yyyy hh:mm:ss ):  8/05/2026 at 14:23:17

* INTERF i0 i1 q vdd vss

.subckt o2_x2 3 8 37 18 41
* NET 3 = i0
* NET 8 = i1
* NET 18 = vdd
* NET 37 = q
* NET 41 = vss
Mtr_00006 16 2 13 18 sky130_fd_pr__pfet_01v8__model L=0.15U W=2.46U AS=0.7134P AD=0.7134P PS=5.5U PD=5.5U
Mtr_00005 13 9 28 18 sky130_fd_pr__pfet_01v8__model L=0.15U W=2.46U AS=0.7134P AD=0.7134P PS=5.5U PD=5.5U
Mtr_00004 38 30 16 18 sky130_fd_pr__pfet_01v8__model L=0.15U W=2.46U AS=0.7134P AD=0.7134P PS=5.5U PD=5.5U
Mtr_00003 42 7 22 41 sky130_fd_pr__nfet_01v8__model L=0.15U W=0.66U AS=0.1914P AD=0.1914P PS=1.9U PD=1.9U
Mtr_00002 22 1 43 41 sky130_fd_pr__nfet_01v8__model L=0.15U W=0.66U AS=0.1914P AD=0.1914P PS=1.9U PD=1.9U
Mtr_00001 36 25 43 41 sky130_fd_pr__nfet_01v8__model L=0.15U W=1.26U AS=0.3654P AD=0.3654P PS=3.1U PD=3.1U
R7_1 4 3 15
R7_2 4 2 480
C7_21 4 41 8.69778e-17
C7_22 2 41 8.69778e-17
R7_3 1 4 576
C7_31 1 41 9.6642e-17
C7_32 4 41 9.6642e-17
R6_1 10 8 15
R6_2 10 9 480
C6_21 10 41 8.69778e-17
C6_22 9 41 8.69778e-17
R6_3 7 10 576
C6_31 7 41 9.6642e-17
C6_32 10 41 9.6642e-17
R4_1 17 16 15
R4_2 17 18 26
C4_21 17 41 6.42888e-17
C4_22 18 41 6.42888e-17
R3_1 23 22 15
R3_2 25 27 15
R3_3 31 28 15
R3_4 32 28 15
R3_5 33 28 15
R3_6 29 28 15
R3_7 25 30 912
C3_71 25 41 1.59459e-16
C3_72 30 41 1.59459e-16
R3_8 32 33 13
C3_81 32 41 5.3574e-17
C3_82 33 41 5.3574e-17
R3_9 31 32 26
C3_91 31 41 6.42888e-17
C3_92 32 41 6.42888e-17
R3_10 29 31 26
C3_101 29 41 6.42888e-17
C3_102 31 41 6.42888e-17
R3_11 21 29 65
C3_111 21 41 1.71437e-16
C3_112 29 41 1.71437e-16
R3_12 26 27 26
C3_121 26 41 6.42888e-17
C3_122 27 41 6.42888e-17
R3_13 24 26 26
C3_131 24 41 7.50036e-17
C3_132 26 41 7.50036e-17
R3_14 21 24 26
C3_141 21 41 6.42888e-17
C3_142 24 41 6.42888e-17
R3_15 23 24 13
C3_151 23 41 5.3574e-17
C3_152 24 41 5.3574e-17
R2_1 37 36 7.5
R2_2 37 38 3.75
R1_1 45 43 7.5
R1_2 44 42 15
R1_3 41 44 26
C1_31 41 41 6.42888e-17
C1_32 44 41 6.42888e-17
R1_4 41 45 26
C1_41 41 41 6.42888e-17
C1_42 45 41 6.42888e-17
.ends o2_x2
