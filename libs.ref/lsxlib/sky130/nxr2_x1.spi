* Spice description of nxr2_x1
* Spice driver version -533603411
* Date ( dd/mm/yyyy hh:mm:ss ):  8/05/2026 at 14:22:51

* INTERF i0 i1 nq nq vdd vss

.subckt nxr2_x1 1 26 71 76 39 64
* NET 1 = i0
* NET 26 = i1
* NET 39 = vdd
* NET 64 = vss
* NET 71 = nq
* NET 76 = nq
Mtr_00012 36 19 43 39 sky130_fd_pr__pfet_01v8__model L=0.15U W=2.34U AS=0.6786P AD=0.6786P PS=5.26U PD=5.26U
Mtr_00011 43 59 75 39 sky130_fd_pr__pfet_01v8__model L=0.15U W=2.34U AS=0.6786P AD=0.6786P PS=5.26U PD=5.26U
Mtr_00010 75 28 42 39 sky130_fd_pr__pfet_01v8__model L=0.15U W=2.34U AS=0.6786P AD=0.6786P PS=5.26U PD=5.26U
Mtr_00009 42 6 35 39 sky130_fd_pr__pfet_01v8__model L=0.15U W=2.34U AS=0.6786P AD=0.6786P PS=5.26U PD=5.26U
Mtr_00008 20 32 36 39 sky130_fd_pr__pfet_01v8__model L=0.15U W=1.26U AS=0.3654P AD=0.3654P PS=3.1U PD=3.1U
Mtr_00007 35 7 58 39 sky130_fd_pr__pfet_01v8__model L=0.15U W=1.26U AS=0.3654P AD=0.3654P PS=3.1U PD=3.1U
Mtr_00006 82 25 67 64 sky130_fd_pr__nfet_01v8__model L=0.15U W=1.14U AS=0.3306P AD=0.3306P PS=2.86U PD=2.86U
Mtr_00005 72 54 82 64 sky130_fd_pr__nfet_01v8__model L=0.15U W=1.14U AS=0.3306P AD=0.3306P PS=2.86U PD=2.86U
Mtr_00004 79 10 72 64 sky130_fd_pr__nfet_01v8__model L=0.15U W=1.14U AS=0.3306P AD=0.3306P PS=2.86U PD=2.86U
Mtr_00003 65 3 79 64 sky130_fd_pr__nfet_01v8__model L=0.15U W=1.14U AS=0.3306P AD=0.3306P PS=2.86U PD=2.86U
Mtr_00002 52 2 65 64 sky130_fd_pr__nfet_01v8__model L=0.15U W=0.66U AS=0.1914P AD=0.1914P PS=1.9U PD=1.9U
Mtr_00001 67 27 11 64 sky130_fd_pr__nfet_01v8__model L=0.15U W=0.66U AS=0.1914P AD=0.1914P PS=1.9U PD=1.9U
R10_1 4 1 15
R10_2 5 1 15
R10_3 5 7 624
C10_31 5 64 1.05501e-16
C10_32 7 64 1.05501e-16
R10_4 5 6 144
C10_41 5 64 2.9798e-17
C10_42 6 64 2.9798e-17
R10_5 2 4 336
C10_51 2 64 5.71799e-17
C10_52 4 64 5.71799e-17
R10_6 4 3 144
C10_61 4 64 2.9798e-17
C10_62 3 64 2.9798e-17
R9_1 10 13 15
R9_2 16 15 15
R9_3 18 17 15
R9_4 22 20 15
R9_5 21 20 15
R9_6 12 11 15
R9_7 21 22 26
C9_71 21 64 6.42888e-17
C9_72 22 64 6.42888e-17
R9_8 17 21 78
C9_81 17 64 1.92866e-16
C9_82 21 64 1.92866e-16
R9_9 12 17 65
C9_91 12 64 1.50007e-16
C9_92 17 64 1.50007e-16
R9_10 16 19 624
C9_101 16 64 1.08722e-16
C9_102 19 64 1.08722e-16
R9_11 16 18 336
C9_111 16 64 6.36227e-17
C9_112 18 64 6.36227e-17
R9_12 14 15 39
C9_121 14 64 9.64332e-17
C9_122 15 64 9.64332e-17
R9_13 13 14 13
C9_131 13 64 3.21444e-17
C9_132 14 64 3.21444e-17
R8_1 28 29 15
R8_2 30 26 15
R8_3 31 26 15
R8_4 27 31 336
C8_41 27 64 5.71799e-17
C8_42 31 64 5.71799e-17
R8_5 25 31 144
C8_51 25 64 2.9798e-17
C8_52 31 64 2.9798e-17
R8_6 30 32 624
C8_61 30 64 1.05501e-16
C8_62 32 64 1.05501e-16
R8_7 29 26 65
C8_71 29 64 1.50007e-16
C8_72 26 64 1.50007e-16
R7_1 37 35 15
R7_2 38 36 15
R7_3 38 39 26
C7_31 38 64 6.42888e-17
C7_32 39 64 6.42888e-17
R7_4 37 39 26
C7_41 37 64 6.42888e-17
C7_42 39 64 6.42888e-17
R6_1 48 42 15
R6_2 47 42 15
R6_3 49 43 15
R6_4 46 43 15
R6_5 44 43 15
R6_6 45 43 15
R6_7 46 49 13
C6_71 46 64 5.3574e-17
C6_72 49 64 5.3574e-17
R6_8 45 46 13
C6_81 45 64 5.3574e-17
C6_82 46 64 5.3574e-17
R6_9 44 45 13
C6_91 44 64 5.3574e-17
C6_92 45 64 5.3574e-17
R6_10 47 48 13
C6_101 47 64 4.28592e-17
C6_102 48 64 4.28592e-17
R6_11 48 49 52
C6_111 48 64 1.28578e-16
C6_112 49 64 1.28578e-16
R5_1 52 53 15
R5_2 60 58 15
R5_3 61 58 15
R5_4 56 55 15
R5_5 57 59 576
C5_51 57 64 1.03085e-16
C5_52 59 64 1.03085e-16
R5_6 54 57 384
C5_61 54 64 7.08708e-17
C5_62 57 64 7.08708e-17
R5_7 56 57 768
C5_71 56 64 1.35299e-16
C5_72 57 64 1.35299e-16
R5_8 61 60 26
C5_81 61 64 6.42888e-17
C5_82 60 64 6.42888e-17
R5_9 55 61 78
C5_91 55 64 1.92866e-16
C5_92 61 64 1.92866e-16
R5_10 53 55 65
C5_101 53 64 1.50007e-16
C5_102 55 64 1.50007e-16
R4_1 66 65 15
R4_2 68 67 15
R4_3 64 68 26
C4_31 64 64 6.42888e-17
C4_32 68 64 6.42888e-17
R4_4 64 66 26
C4_41 64 64 6.42888e-17
C4_42 66 64 6.42888e-17
R3_1 73 72 15
R3_2 74 72 15
R3_3 76 75 5
R3_4 71 76 26
C3_41 71 64 6.42888e-17
C3_42 76 64 6.42888e-17
R3_5 71 74 26
C3_51 71 64 6.42888e-17
C3_52 74 64 6.42888e-17
R3_6 73 74 13
C3_61 73 64 5.3574e-17
C3_62 74 64 5.3574e-17
.ends nxr2_x1
