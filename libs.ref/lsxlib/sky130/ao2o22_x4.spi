* Spice description of ao2o22_x4
* Spice driver version 244005805
* Date ( dd/mm/yyyy hh:mm:ss ):  8/05/2026 at 14:22:51

* INTERF i0 i1 i2 i3 q vdd vss

.subckt ao2o22_x4 41 36 30 48 25 21 80
* NET 21 = vdd
* NET 25 = q
* NET 30 = i2
* NET 36 = i1
* NET 41 = i0
* NET 48 = i3
* NET 80 = vss
Mtr_00012 9 73 26 21 sky130_fd_pr__pfet_01v8__model L=0.15U W=2.46U AS=0.7134P AD=0.7134P PS=5.5U PD=5.5U
Mtr_00011 26 72 7 21 sky130_fd_pr__pfet_01v8__model L=0.15U W=2.46U AS=0.7134P AD=0.7134P PS=5.5U PD=5.5U
Mtr_00010 1 44 13 21 sky130_fd_pr__pfet_01v8__model L=0.15U W=1.26U AS=0.3654P AD=0.3654P PS=3.1U PD=3.1U
Mtr_00009 4 32 74 21 sky130_fd_pr__pfet_01v8__model L=0.15U W=1.26U AS=0.3654P AD=0.3654P PS=3.1U PD=3.1U
Mtr_00008 14 50 4 21 sky130_fd_pr__pfet_01v8__model L=0.15U W=1.26U AS=0.3654P AD=0.3654P PS=3.1U PD=3.1U
Mtr_00007 74 38 1 21 sky130_fd_pr__pfet_01v8__model L=0.15U W=1.26U AS=0.3654P AD=0.3654P PS=3.1U PD=3.1U
Mtr_00006 24 66 85 80 sky130_fd_pr__nfet_01v8__model L=0.15U W=1.26U AS=0.3654P AD=0.3654P PS=3.1U PD=3.1U
Mtr_00005 83 65 24 80 sky130_fd_pr__nfet_01v8__model L=0.15U W=1.26U AS=0.3654P AD=0.3654P PS=3.1U PD=3.1U
Mtr_00004 55 29 81 80 sky130_fd_pr__nfet_01v8__model L=0.15U W=0.66U AS=0.1914P AD=0.1914P PS=1.9U PD=1.9U
Mtr_00003 81 47 57 80 sky130_fd_pr__nfet_01v8__model L=0.15U W=0.66U AS=0.1914P AD=0.1914P PS=1.9U PD=1.9U
Mtr_00002 53 43 63 80 sky130_fd_pr__nfet_01v8__model L=0.15U W=0.66U AS=0.1914P AD=0.1914P PS=1.9U PD=1.9U
Mtr_00001 63 35 55 80 sky130_fd_pr__nfet_01v8__model L=0.15U W=0.66U AS=0.1914P AD=0.1914P PS=1.9U PD=1.9U
R9_1 12 9 15
R9_2 20 9 15
R9_3 16 9 15
R9_4 9 10 15
R9_5 19 7 15
R9_6 11 7 15
R9_7 15 7 15
R9_8 8 7 15
R9_9 18 14 15
R9_10 17 13 15
R9_11 17 21 26
C9_111 17 80 6.42888e-17
C9_112 21 80 6.42888e-17
R9_12 18 21 26
C9_121 18 80 6.42888e-17
C9_122 21 80 6.42888e-17
R9_13 19 21 26
C9_131 19 80 6.42888e-17
C9_132 21 80 6.42888e-17
R9_14 15 19 13
C9_141 15 80 5.3574e-17
C9_142 19 80 5.3574e-17
R9_15 11 15 26
C9_151 11 80 6.42888e-17
C9_152 15 80 6.42888e-17
R9_16 8 11 26
C9_161 8 80 6.42888e-17
C9_162 11 80 6.42888e-17
R9_17 20 21 26
C9_171 20 80 6.42888e-17
C9_172 21 80 6.42888e-17
R9_18 16 20 13
C9_181 16 80 5.3574e-17
C9_182 20 80 5.3574e-17
R9_19 12 16 26
C9_191 12 80 6.42888e-17
C9_192 16 80 6.42888e-17
R9_20 10 12 26
C9_201 10 80 6.42888e-17
C9_202 12 80 6.42888e-17
R8_1 25 24 7.5
R8_2 25 26 3.75
R7_1 31 30 15
R7_2 31 32 672
C7_21 31 80 1.19192e-16
C7_22 32 80 1.19192e-16
R7_3 29 31 576
C7_31 29 80 9.6642e-17
C7_32 31 80 9.6642e-17
R6_1 37 36 15
R6_2 37 38 672
C6_21 37 80 1.19192e-16
C6_22 38 80 1.19192e-16
R6_3 35 37 576
C6_31 35 80 9.6642e-17
C6_32 37 80 9.6642e-17
R5_1 42 41 15
R5_2 42 44 672
C5_21 42 80 1.19192e-16
C5_22 44 80 1.19192e-16
R5_3 43 42 576
C5_31 43 80 9.6642e-17
C5_32 42 80 9.6642e-17
R4_1 49 48 15
R4_2 49 50 672
C4_21 49 80 1.19192e-16
C4_22 50 80 1.19192e-16
R4_3 47 49 576
C4_31 47 80 9.6642e-17
C4_32 49 80 9.6642e-17
R3_1 56 55 15
R3_2 54 53 15
R3_3 58 57 15
R3_4 58 60 13
C3_41 58 80 5.3574e-17
C3_42 60 80 5.3574e-17
R3_5 59 60 52
C3_51 59 80 1.28578e-16
C3_52 60 80 1.28578e-16
R3_6 56 59 13
C3_61 56 80 5.3574e-17
C3_62 59 80 5.3574e-17
R3_7 54 56 52
C3_71 54 80 1.28578e-16
C3_72 56 80 1.28578e-16
R2_1 64 63 15
R2_2 75 74 15
R2_3 77 74 15
R2_4 71 70 15
R2_5 71 73 480
C2_51 71 80 8.69778e-17
C2_52 73 80 8.69778e-17
R2_6 66 71 480
C2_61 66 80 8.0535e-17
C2_62 71 80 8.0535e-17
R2_7 71 72 480
C2_71 71 80 8.69778e-17
C2_72 72 80 8.69778e-17
R2_8 65 71 480
C2_81 65 80 8.0535e-17
C2_82 71 80 8.0535e-17
R2_9 69 70 26
C2_91 69 80 6.42888e-17
C2_92 70 80 6.42888e-17
R2_10 69 76 78
C2_101 69 80 1.82152e-16
C2_102 76 80 1.82152e-16
R2_11 75 76 65
C2_111 75 80 1.60722e-16
C2_112 76 80 1.60722e-16
R2_12 75 77 26
C2_121 75 80 6.42888e-17
C2_122 77 80 6.42888e-17
R2_13 68 75 104
C2_131 68 80 2.35726e-16
C2_132 75 80 2.35726e-16
R2_14 67 68 26
C2_141 67 80 6.42888e-17
C2_142 68 80 6.42888e-17
R2_15 64 67 13
C2_151 64 80 5.3574e-17
C2_152 67 80 5.3574e-17
R1_1 82 81 15
R1_2 86 85 15
R1_3 88 85 15
R1_4 87 83 15
R1_5 84 83 15
R1_6 84 87 26
C1_61 84 80 7.50036e-17
C1_62 87 80 7.50036e-17
R1_7 80 84 26
C1_71 80 80 6.42888e-17
C1_72 84 80 6.42888e-17
R1_8 86 88 26
C1_81 86 80 7.50036e-17
C1_82 88 80 7.50036e-17
R1_9 80 86 26
C1_91 80 80 6.42888e-17
C1_92 86 80 6.42888e-17
R1_10 80 82 26
C1_101 80 80 6.42888e-17
C1_102 82 80 6.42888e-17
.ends ao2o22_x4
