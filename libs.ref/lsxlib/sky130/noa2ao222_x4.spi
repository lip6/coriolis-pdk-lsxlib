* Spice description of noa2ao222_x4
* Spice driver version -1225303123
* Date ( dd/mm/yyyy hh:mm:ss ):  8/05/2026 at 14:23:17

* INTERF i0 i1 i2 i3 i4 nq vdd vss

.subckt noa2ao222_x4 71 65 54 3 60 33 29 105
* NET 3 = i3
* NET 29 = vdd
* NET 33 = nq
* NET 54 = i2
* NET 60 = i4
* NET 65 = i1
* NET 71 = i0
* NET 105 = vss
Mtr_00016 23 74 8 29 sky130_fd_pr__pfet_01v8__model L=0.15U W=1.26U AS=0.3654P AD=0.3654P PS=3.1U PD=3.1U
Mtr_00015 23 68 9 29 sky130_fd_pr__pfet_01v8__model L=0.15U W=1.26U AS=0.3654P AD=0.3654P PS=3.1U PD=3.1U
Mtr_00014 98 62 9 29 sky130_fd_pr__pfet_01v8__model L=0.15U W=1.26U AS=0.3654P AD=0.3654P PS=3.1U PD=3.1U
Mtr_00013 17 102 48 29 sky130_fd_pr__pfet_01v8__model L=0.15U W=1.26U AS=0.3654P AD=0.3654P PS=3.1U PD=3.1U
Mtr_00012 19 47 34 29 sky130_fd_pr__pfet_01v8__model L=0.15U W=2.46U AS=0.7134P AD=0.7134P PS=5.5U PD=5.5U
Mtr_00011 34 46 17 29 sky130_fd_pr__pfet_01v8__model L=0.15U W=2.46U AS=0.7134P AD=0.7134P PS=5.5U PD=5.5U
Mtr_00010 77 55 98 29 sky130_fd_pr__pfet_01v8__model L=0.15U W=2.46U AS=0.7134P AD=0.7134P PS=5.5U PD=5.5U
Mtr_00009 7 2 77 29 sky130_fd_pr__pfet_01v8__model L=0.15U W=2.46U AS=0.7134P AD=0.7134P PS=5.5U PD=5.5U
Mtr_00008 82 1 108 105 sky130_fd_pr__nfet_01v8__model L=0.15U W=0.66U AS=0.1914P AD=0.1914P PS=1.9U PD=1.9U
Mtr_00007 88 72 106 105 sky130_fd_pr__nfet_01v8__model L=0.15U W=0.66U AS=0.1914P AD=0.1914P PS=1.9U PD=1.9U
Mtr_00006 108 53 80 105 sky130_fd_pr__nfet_01v8__model L=0.15U W=0.66U AS=0.1914P AD=0.1914P PS=1.9U PD=1.9U
Mtr_00005 80 59 91 105 sky130_fd_pr__nfet_01v8__model L=0.15U W=0.66U AS=0.1914P AD=0.1914P PS=1.9U PD=1.9U
Mtr_00004 91 66 88 105 sky130_fd_pr__nfet_01v8__model L=0.15U W=0.66U AS=0.1914P AD=0.1914P PS=1.9U PD=1.9U
Mtr_00003 37 93 110 105 sky130_fd_pr__nfet_01v8__model L=0.15U W=0.66U AS=0.1914P AD=0.1914P PS=1.9U PD=1.9U
Mtr_00002 110 40 32 105 sky130_fd_pr__nfet_01v8__model L=0.15U W=1.26U AS=0.3654P AD=0.3654P PS=3.1U PD=3.1U
Mtr_00001 32 42 112 105 sky130_fd_pr__nfet_01v8__model L=0.15U W=1.26U AS=0.3654P AD=0.3654P PS=3.1U PD=3.1U
R14_1 4 3 15
R14_2 4 2 528
C14_21 4 105 9.34206e-17
C14_22 2 105 9.34206e-17
R14_3 1 4 528
C14_31 1 105 9.01992e-17
C14_32 4 105 9.01992e-17
R13_1 14 7 15
R13_2 13 9 15
R13_3 11 9 15
R13_4 10 8 15
R13_5 12 8 15
R13_6 10 12 13
C13_61 10 105 5.3574e-17
C13_62 12 105 5.3574e-17
R13_7 10 11 52
C13_71 10 105 1.28578e-16
C13_72 11 105 1.28578e-16
R13_8 11 13 13
C13_81 11 105 5.3574e-17
C13_82 13 105 5.3574e-17
R13_9 13 14 78
C13_91 13 105 1.82152e-16
C13_92 14 105 1.82152e-16
R12_1 24 17 15
R12_2 21 17 15
R12_3 27 17 15
R12_4 17 18 15
R12_5 25 19 15
R12_6 22 19 15
R12_7 28 19 15
R12_8 20 19 15
R12_9 26 23 15
R12_10 26 29 26
C12_101 26 105 6.42888e-17
C12_102 29 105 6.42888e-17
R12_11 28 29 26
C12_111 28 105 6.42888e-17
C12_112 29 105 6.42888e-17
R12_12 25 28 26
C12_121 25 105 6.42888e-17
C12_122 28 105 6.42888e-17
R12_13 22 25 26
C12_131 22 105 6.42888e-17
C12_132 25 105 6.42888e-17
R12_14 20 22 13
C12_141 20 105 5.3574e-17
C12_142 22 105 5.3574e-17
R12_15 27 29 26
C12_151 27 105 6.42888e-17
C12_152 29 105 6.42888e-17
R12_16 24 27 26
C12_161 24 105 6.42888e-17
C12_162 27 105 6.42888e-17
R12_17 21 24 26
C12_171 21 105 6.42888e-17
C12_172 24 105 6.42888e-17
R12_18 18 21 13
C12_181 18 105 5.3574e-17
C12_182 21 105 5.3574e-17
R11_1 33 32 7.5
R11_2 33 34 3.75
R10_1 38 37 15
R10_2 45 44 15
R10_3 50 48 15
R10_4 49 48 15
R10_5 45 47 528
C10_51 45 105 9.34206e-17
C10_52 47 105 9.34206e-17
R10_6 42 45 432
C10_61 42 105 7.40922e-17
C10_62 45 105 7.40922e-17
R10_7 45 46 528
C10_71 45 105 9.34206e-17
C10_72 46 105 9.34206e-17
R10_8 40 45 432
C10_81 40 105 7.40922e-17
C10_82 45 105 7.40922e-17
R10_9 49 50 26
C10_91 49 105 6.42888e-17
C10_92 50 105 6.42888e-17
R10_10 43 49 78
C10_101 43 105 1.82152e-16
C10_102 49 105 1.82152e-16
R10_11 43 44 26
C10_111 43 105 7.50036e-17
C10_112 44 105 7.50036e-17
R10_12 41 44 39
C10_121 41 105 1.07148e-16
C10_122 44 105 1.07148e-16
R10_13 39 41 26
C10_131 39 105 7.50036e-17
C10_132 41 105 7.50036e-17
R10_14 38 39 13
C10_141 38 105 5.3574e-17
C10_142 39 105 5.3574e-17
R9_1 56 54 15
R9_2 56 55 528
C9_21 56 105 9.34206e-17
C9_22 55 105 9.34206e-17
R9_3 53 56 480
C9_31 53 105 8.77832e-17
C9_32 56 105 8.77832e-17
R8_1 61 60 15
R8_2 61 62 720
C8_21 61 105 1.23219e-16
C8_22 62 105 1.23219e-16
R8_3 59 61 528
C8_31 59 105 9.01992e-17
C8_32 61 105 9.01992e-17
R7_1 67 65 15
R7_2 67 68 720
C7_21 67 105 1.23219e-16
C7_22 68 105 1.23219e-16
R7_3 66 67 528
C7_31 66 105 9.01992e-17
C7_32 67 105 9.01992e-17
R6_1 73 71 15
R6_2 73 74 720
C6_21 73 105 1.25635e-16
C6_22 74 105 1.25635e-16
R6_3 72 73 528
C6_31 72 105 9.01992e-17
C6_32 73 105 9.01992e-17
R4_1 81 80 15
R4_2 83 82 15
R4_3 83 85 13
C4_31 83 105 5.3574e-17
C4_32 85 105 5.3574e-17
R4_4 84 85 52
C4_41 84 105 1.28578e-16
C4_42 85 105 1.28578e-16
R4_5 81 84 13
C4_51 81 105 5.3574e-17
C4_52 84 105 5.3574e-17
R2_1 92 91 15
R2_2 97 96 15
R2_3 100 98 15
R2_4 101 98 15
R2_5 99 98 15
R2_6 97 102 912
C2_61 97 105 1.57849e-16
C2_62 102 105 1.57849e-16
R2_7 93 97 336
C2_71 93 105 5.79852e-17
C2_72 97 105 5.79852e-17
R2_8 100 101 26
C2_81 100 105 6.42888e-17
C2_82 101 105 6.42888e-17
R2_9 99 100 26
C2_91 99 105 6.42888e-17
C2_92 100 105 6.42888e-17
R2_10 95 99 52
C2_101 95 105 1.17863e-16
C2_102 99 105 1.17863e-16
R2_11 95 96 91
C2_111 95 105 2.14296e-16
C2_112 96 105 2.14296e-16
R2_12 94 95 13
C2_121 94 105 5.3574e-17
C2_122 95 105 5.3574e-17
R2_13 92 94 39
C2_131 92 105 1.07148e-16
C2_132 94 105 1.07148e-16
R1_1 109 108 15
R1_2 113 112 15
R1_3 114 112 15
R1_4 111 110 15
R1_5 107 106 15
R1_6 105 107 26
C1_61 105 105 6.42888e-17
C1_62 107 105 6.42888e-17
R1_7 105 111 26
C1_71 105 105 6.42888e-17
C1_72 111 105 6.42888e-17
R1_8 113 114 26
C1_81 113 105 7.50036e-17
C1_82 114 105 7.50036e-17
R1_9 105 113 26
C1_91 105 105 6.42888e-17
C1_92 113 105 6.42888e-17
R1_10 105 109 26
C1_101 105 105 6.42888e-17
C1_102 109 105 6.42888e-17
.ends noa2ao222_x4
