* Spice description of nmx3_x1
* Spice driver version 1453308845
* Date ( dd/mm/yyyy hh:mm:ss ):  8/05/2026 at 14:22:52

* INTERF cmd0 cmd1 i0 i1 i2 nq vdd vss

.subckt nmx3_x1 22 59 17 71 53 104 83 112
* NET 17 = i0
* NET 22 = cmd0
* NET 53 = i2
* NET 59 = cmd1
* NET 71 = i1
* NET 83 = vdd
* NET 104 = nq
* NET 112 = vss
Mtr_00018 78 29 43 83 sky130_fd_pr__pfet_01v8__model L=0.15U W=0.78U AS=0.2262P AD=0.2262P PS=2.14U PD=2.14U
Mtr_00017 125 61 77 83 sky130_fd_pr__pfet_01v8__model L=0.15U W=0.78U AS=0.2262P AD=0.2262P PS=2.14U PD=2.14U
Mtr_00016 106 19 1 83 sky130_fd_pr__pfet_01v8__model L=0.15U W=1.14U AS=0.3306P AD=0.3306P PS=2.86U PD=2.86U
Mtr_00015 13 55 7 83 sky130_fd_pr__pfet_01v8__model L=0.15U W=1.14U AS=0.3306P AD=0.3306P PS=2.86U PD=2.86U
Mtr_00014 105 67 13 83 sky130_fd_pr__pfet_01v8__model L=0.15U W=1.14U AS=0.3306P AD=0.3306P PS=2.86U PD=2.86U
Mtr_00013 4 128 105 83 sky130_fd_pr__pfet_01v8__model L=0.15U W=1.14U AS=0.3306P AD=0.3306P PS=2.86U PD=2.86U
Mtr_00012 1 30 79 83 sky130_fd_pr__pfet_01v8__model L=0.15U W=1.14U AS=0.3306P AD=0.3306P PS=2.86U PD=2.86U
Mtr_00011 79 45 8 83 sky130_fd_pr__pfet_01v8__model L=0.15U W=1.14U AS=0.3306P AD=0.3306P PS=2.86U PD=2.86U
Mtr_00010 8 74 4 83 sky130_fd_pr__pfet_01v8__model L=0.15U W=1.14U AS=0.3306P AD=0.3306P PS=2.86U PD=2.86U
Mtr_00009 101 16 49 112 sky130_fd_pr__nfet_01v8__model L=0.15U W=0.54U AS=0.1566P AD=0.1566P PS=1.66U PD=1.66U
Mtr_00008 115 23 88 112 sky130_fd_pr__nfet_01v8__model L=0.15U W=0.54U AS=0.1566P AD=0.1566P PS=1.66U PD=1.66U
Mtr_00007 49 35 115 112 sky130_fd_pr__nfet_01v8__model L=0.15U W=0.54U AS=0.1566P AD=0.1566P PS=1.66U PD=1.66U
Mtr_00006 38 27 117 112 sky130_fd_pr__nfet_01v8__model L=0.15U W=0.42U AS=0.1218P AD=0.1218P PS=1.42U PD=1.42U
Mtr_00005 113 58 121 112 sky130_fd_pr__nfet_01v8__model L=0.15U W=0.42U AS=0.1218P AD=0.1218P PS=1.42U PD=1.42U
Mtr_00004 95 52 86 112 sky130_fd_pr__nfet_01v8__model L=0.15U W=0.54U AS=0.1566P AD=0.1566P PS=1.66U PD=1.66U
Mtr_00003 92 60 98 112 sky130_fd_pr__nfet_01v8__model L=0.15U W=0.54U AS=0.1566P AD=0.1566P PS=1.66U PD=1.66U
Mtr_00002 98 123 95 112 sky130_fd_pr__nfet_01v8__model L=0.15U W=0.54U AS=0.1566P AD=0.1566P PS=1.66U PD=1.66U
Mtr_00001 88 72 92 112 sky130_fd_pr__nfet_01v8__model L=0.15U W=0.54U AS=0.1566P AD=0.1566P PS=1.66U PD=1.66U
R16_1 9 7 15
R16_2 10 8 15
R16_3 9 10 104
C16_31 9 112 2.4644e-16
C16_32 10 112 2.4644e-16
R14_1 18 17 15
R14_2 19 17 15
R14_3 16 18 528
C14_31 16 112 9.34206e-17
C14_32 18 112 9.34206e-17
R13_1 28 22 15
R13_2 23 24 48
C13_21 23 112 1.28856e-17
C13_22 24 112 1.28856e-17
R13_3 27 29 576
C13_31 27 112 1.0389e-16
C13_32 29 112 1.0389e-16
R13_4 24 25 192
C13_41 24 112 3.86568e-17
C13_42 25 112 3.86568e-17
R13_5 28 29 528
C13_51 28 112 9.01992e-17
C13_52 29 112 9.01992e-17
R13_6 25 26 48
C13_61 25 112 1.28856e-17
C13_62 26 112 1.28856e-17
R13_7 31 30 48
C13_71 31 112 1.28856e-17
C13_72 30 112 1.28856e-17
R13_8 28 31 384
C13_81 28 112 6.4428e-17
C13_82 31 112 6.4428e-17
R13_9 26 28 336
C13_91 26 112 5.79852e-17
C13_92 28 112 5.79852e-17
R12_1 42 38 15
R12_2 44 43 15
R12_3 35 36 15
R12_4 40 39 15
R12_5 46 45 48
C12_51 46 112 1.28856e-17
C12_52 45 112 1.28856e-17
R12_6 40 46 720
C12_61 40 112 1.22413e-16
C12_62 46 112 1.22413e-16
R12_7 34 39 13
C12_71 34 112 5.3574e-17
C12_72 39 112 5.3574e-17
R12_8 36 37 13
C12_81 36 112 4.28592e-17
C12_82 37 112 4.28592e-17
R12_9 34 36 26
C12_91 34 112 8.57184e-17
C12_92 36 112 8.57184e-17
R12_10 37 41 13
C12_101 37 112 5.3574e-17
C12_102 41 112 5.3574e-17
R12_11 41 42 26
C12_111 41 112 5.89314e-17
C12_112 42 112 5.89314e-17
R12_12 42 44 52
C12_121 42 112 1.39292e-16
C12_122 44 112 1.39292e-16
R10_1 54 53 15
R10_2 54 55 768
C10_21 54 112 1.28856e-16
C10_22 55 112 1.28856e-16
R10_3 52 54 528
C10_31 52 112 9.34206e-17
C10_32 54 112 9.34206e-17
R9_1 62 59 15
R9_2 67 68 15
R9_3 60 66 384
C9_31 60 112 6.76494e-17
C9_32 66 112 6.76494e-17
R9_4 63 66 192
C9_41 63 112 3.2214e-17
C9_42 66 112 3.2214e-17
R9_5 63 64 288
C9_51 63 112 5.15424e-17
C9_52 64 112 5.15424e-17
R9_6 65 64 48
C9_61 65 112 1.28856e-17
C9_62 64 112 1.28856e-17
R9_7 65 67 528
C9_71 65 112 9.50313e-17
C9_72 67 112 9.50313e-17
R9_8 59 68 52
C9_81 59 112 1.28578e-16
C9_82 68 112 1.28578e-16
R9_9 62 61 288
C9_91 62 112 4.8321e-17
C9_92 61 112 4.8321e-17
R9_10 58 62 288
C9_101 58 112 5.15424e-17
C9_102 62 112 5.15424e-17
R8_1 73 71 15
R8_2 73 74 768
C8_21 73 112 1.28856e-16
C8_22 74 112 1.28856e-16
R8_3 72 73 528
C8_31 72 112 9.34206e-17
C8_32 73 112 9.34206e-17
R7_1 80 77 15
R7_2 82 78 15
R7_3 81 79 15
R7_4 81 83 26
C7_41 81 112 6.42888e-17
C7_42 83 112 6.42888e-17
R7_5 82 83 26
C7_51 82 112 6.42888e-17
C7_52 83 112 6.42888e-17
R7_6 80 83 26
C7_61 80 112 6.42888e-17
C7_62 83 112 6.42888e-17
R6_1 87 86 15
R6_2 89 88 15
R6_3 87 89 104
C6_31 87 112 2.4644e-16
C6_32 89 112 2.4644e-16
R3_1 99 98 15
R3_2 109 106 15
R3_3 107 105 15
R3_4 103 101 15
R3_5 103 102 13
C3_51 103 112 5.3574e-17
C3_52 102 112 5.3574e-17
R3_6 102 104 26
C3_61 102 112 6.42888e-17
C3_62 104 112 6.42888e-17
R3_7 109 104 26
C3_71 109 112 7.50036e-17
C3_72 104 112 7.50036e-17
R3_8 108 109 91
C3_81 108 112 2.25011e-16
C3_82 109 112 2.25011e-16
R3_9 107 108 26
C3_91 107 112 7.50036e-17
C3_92 108 112 7.50036e-17
R3_10 100 108 130
C3_101 100 112 3.00014e-16
C3_102 108 112 3.00014e-16
R3_11 99 100 26
C3_111 99 112 7.50036e-17
C3_112 100 112 7.50036e-17
R2_1 114 113 15
R2_2 118 117 15
R2_3 116 115 15
R2_4 112 116 26
C2_41 112 112 6.42888e-17
C2_42 116 112 6.42888e-17
R2_5 112 118 26
C2_51 112 112 6.42888e-17
C2_52 118 112 6.42888e-17
R2_6 112 114 26
C2_61 112 112 6.42888e-17
C2_62 114 112 6.42888e-17
R1_1 122 121 15
R1_2 123 124 15
R1_3 126 125 15
R1_4 128 129 15
R1_5 127 129 13
C1_51 127 112 5.3574e-17
C1_52 129 112 5.3574e-17
R1_6 126 127 65
C1_61 126 112 1.50007e-16
C1_62 127 112 1.50007e-16
R1_7 122 126 65
C1_71 122 112 1.71437e-16
C1_72 126 112 1.71437e-16
R1_8 122 124 26
C1_81 122 112 7.50036e-17
C1_82 124 112 7.50036e-17
.ends nmx3_x1
