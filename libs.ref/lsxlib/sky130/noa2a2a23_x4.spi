* Spice description of noa2a2a23_x4
* Spice driver version 312912813
* Date ( dd/mm/yyyy hh:mm:ss ):  8/05/2026 at 14:22:51

* INTERF i0 i1 i2 i3 i4 i5 nq vdd vss

.subckt noa2a2a23_x4 70 88 77 83 23 29 19 50 117
* NET 19 = nq
* NET 23 = i4
* NET 29 = i5
* NET 50 = vdd
* NET 70 = i0
* NET 77 = i2
* NET 83 = i3
* NET 88 = i1
* NET 117 = vss
Mtr_00018 11 85 2 50 sky130_fd_pr__pfet_01v8__model L=0.15U W=1.26U AS=0.3654P AD=0.3654P PS=3.1U PD=3.1U
Mtr_00017 3 79 11 50 sky130_fd_pr__pfet_01v8__model L=0.15U W=1.26U AS=0.3654P AD=0.3654P PS=3.1U PD=3.1U
Mtr_00016 2 91 107 50 sky130_fd_pr__pfet_01v8__model L=0.15U W=1.26U AS=0.3654P AD=0.3654P PS=3.1U PD=3.1U
Mtr_00015 42 26 13 50 sky130_fd_pr__pfet_01v8__model L=0.15U W=1.26U AS=0.3654P AD=0.3654P PS=3.1U PD=3.1U
Mtr_00014 13 32 41 50 sky130_fd_pr__pfet_01v8__model L=0.15U W=1.26U AS=0.3654P AD=0.3654P PS=3.1U PD=3.1U
Mtr_00013 107 73 1 50 sky130_fd_pr__pfet_01v8__model L=0.15U W=1.26U AS=0.3654P AD=0.3654P PS=3.1U PD=3.1U
Mtr_00012 62 111 35 50 sky130_fd_pr__pfet_01v8__model L=0.15U W=1.26U AS=0.3654P AD=0.3654P PS=3.1U PD=3.1U
Mtr_00011 20 60 35 50 sky130_fd_pr__pfet_01v8__model L=0.15U W=2.46U AS=0.7134P AD=0.7134P PS=5.5U PD=5.5U
Mtr_00010 37 61 20 50 sky130_fd_pr__pfet_01v8__model L=0.15U W=2.46U AS=0.7134P AD=0.7134P PS=5.5U PD=5.5U
Mtr_00009 67 24 122 117 sky130_fd_pr__nfet_01v8__model L=0.15U W=0.66U AS=0.1914P AD=0.1914P PS=1.9U PD=1.9U
Mtr_00008 94 76 120 117 sky130_fd_pr__nfet_01v8__model L=0.15U W=0.66U AS=0.1914P AD=0.1914P PS=1.9U PD=1.9U
Mtr_00007 97 82 94 117 sky130_fd_pr__nfet_01v8__model L=0.15U W=0.66U AS=0.1914P AD=0.1914P PS=1.9U PD=1.9U
Mtr_00006 114 89 97 117 sky130_fd_pr__nfet_01v8__model L=0.15U W=0.66U AS=0.1914P AD=0.1914P PS=1.9U PD=1.9U
Mtr_00005 118 71 114 117 sky130_fd_pr__nfet_01v8__model L=0.15U W=0.66U AS=0.1914P AD=0.1914P PS=1.9U PD=1.9U
Mtr_00004 100 30 67 117 sky130_fd_pr__nfet_01v8__model L=0.15U W=0.66U AS=0.1914P AD=0.1914P PS=1.9U PD=1.9U
Mtr_00003 124 55 18 117 sky130_fd_pr__nfet_01v8__model L=0.15U W=1.26U AS=0.3654P AD=0.3654P PS=3.1U PD=3.1U
Mtr_00002 18 56 126 117 sky130_fd_pr__nfet_01v8__model L=0.15U W=1.26U AS=0.3654P AD=0.3654P PS=3.1U PD=3.1U
Mtr_00001 124 104 53 117 sky130_fd_pr__nfet_01v8__model L=0.15U W=0.66U AS=0.1914P AD=0.1914P PS=1.9U PD=1.9U
R16_1 7 2 15
R16_2 5 2 15
R16_3 8 3 15
R16_4 6 1 15
R16_5 4 1 15
R16_6 4 6 13
C16_61 4 117 5.3574e-17
C16_62 6 117 5.3574e-17
R16_7 7 8 52
C16_71 7 117 1.28578e-16
C16_72 8 117 1.28578e-16
R16_8 6 7 52
C16_81 6 117 1.28578e-16
C16_82 7 117 1.28578e-16
R16_9 5 7 13
C16_91 5 117 5.3574e-17
C16_92 7 117 5.3574e-17
R15_1 12 11 15
R15_2 14 13 15
R15_3 15 13 15
R15_4 14 15 13
C15_41 14 117 5.3574e-17
C15_42 15 117 5.3574e-17
R15_5 12 14 78
C15_51 12 117 1.92866e-16
C15_52 14 117 1.92866e-16
R14_1 19 18 7.5
R14_2 19 20 3.75
R13_1 25 23 15
R13_2 25 26 720
C13_21 25 117 1.25635e-16
C13_22 26 117 1.25635e-16
R13_3 24 25 528
C13_31 24 117 9.01992e-17
C13_32 25 117 9.01992e-17
R12_1 31 29 15
R12_2 31 32 720
C12_21 31 117 1.25635e-16
C12_22 32 117 1.25635e-16
R12_3 30 31 528
C12_31 30 117 9.01992e-17
C12_32 31 117 9.01992e-17
R11_1 35 36 15
R11_2 35 44 15
R11_3 35 39 15
R11_4 35 48 15
R11_5 49 37 15
R11_6 40 37 15
R11_7 45 37 15
R11_8 38 37 15
R11_9 43 42 15
R11_10 47 42 15
R11_11 46 41 15
R11_12 46 50 26
C11_121 46 117 6.42888e-17
C11_122 50 117 6.42888e-17
R11_13 47 50 26
C11_131 47 117 6.42888e-17
C11_132 50 117 6.42888e-17
R11_14 43 47 13
C11_141 43 117 5.3574e-17
C11_142 47 117 5.3574e-17
R11_15 49 50 26
C11_151 49 117 6.42888e-17
C11_152 50 117 6.42888e-17
R11_16 45 49 13
C11_161 45 117 5.3574e-17
C11_162 49 117 5.3574e-17
R11_17 40 45 26
C11_171 40 117 6.42888e-17
C11_172 45 117 6.42888e-17
R11_18 38 40 26
C11_181 38 117 6.42888e-17
C11_182 40 117 6.42888e-17
R11_19 48 50 26
C11_191 48 117 6.42888e-17
C11_192 50 117 6.42888e-17
R11_20 44 48 13
C11_201 44 117 5.3574e-17
C11_202 48 117 5.3574e-17
R11_21 39 44 26
C11_211 39 117 6.42888e-17
C11_212 44 117 6.42888e-17
R11_22 36 39 26
C11_221 36 117 6.42888e-17
C11_222 39 117 6.42888e-17
R10_1 54 53 15
R10_2 64 62 15
R10_3 63 62 15
R10_4 59 58 15
R10_5 59 61 528
C10_51 59 117 9.34206e-17
C10_52 61 117 9.34206e-17
R10_6 56 59 432
C10_61 56 117 7.40922e-17
C10_62 59 117 7.40922e-17
R10_7 59 60 528
C10_71 59 117 9.34206e-17
C10_72 60 117 9.34206e-17
R10_8 55 59 432
C10_81 55 117 7.40922e-17
C10_82 59 117 7.40922e-17
R10_9 57 58 26
C10_91 57 117 7.50036e-17
C10_92 58 117 7.50036e-17
R10_10 63 64 13
C10_101 63 117 5.3574e-17
C10_102 64 117 5.3574e-17
R10_11 57 63 78
C10_111 57 117 1.92866e-16
C10_112 63 117 1.92866e-16
R10_12 54 57 65
C10_121 54 117 1.60722e-16
C10_122 57 117 1.60722e-16
R8_1 72 70 15
R8_2 72 73 720
C8_21 72 117 1.25635e-16
C8_22 73 117 1.25635e-16
R8_3 71 72 528
C8_31 71 117 9.01992e-17
C8_32 72 117 9.01992e-17
R7_1 78 77 15
R7_2 78 79 720
C7_21 78 117 1.25635e-16
C7_22 79 117 1.25635e-16
R7_3 76 78 528
C7_31 76 117 9.01992e-17
C7_32 78 117 9.01992e-17
R6_1 84 83 15
R6_2 84 85 720
C6_21 84 117 1.25635e-16
C6_22 85 117 1.25635e-16
R6_3 82 84 528
C6_31 82 117 9.01992e-17
C6_32 84 117 9.01992e-17
R5_1 90 88 15
R5_2 90 91 720
C5_21 90 117 1.25635e-16
C5_22 91 117 1.25635e-16
R5_3 89 90 528
C5_31 89 117 9.01992e-17
C5_32 90 117 9.01992e-17
R3_1 98 97 15
R3_2 110 107 15
R3_3 106 105 15
R3_4 101 100 15
R3_5 106 111 720
C3_51 106 117 1.25635e-16
C3_52 111 117 1.25635e-16
R3_6 104 106 528
C3_61 104 117 9.01992e-17
C3_62 106 117 9.01992e-17
R3_7 101 102 13
C3_71 101 117 5.3574e-17
C3_72 102 117 5.3574e-17
R3_8 103 105 39
C3_81 103 117 1.07148e-16
C3_82 105 117 1.07148e-16
R3_9 109 110 13
C3_91 109 117 5.3574e-17
C3_92 110 117 5.3574e-17
R3_10 102 103 52
C3_101 102 117 1.39292e-16
C3_102 103 117 1.39292e-16
R3_11 99 102 78
C3_111 99 117 1.92866e-16
C3_112 102 117 1.92866e-16
R3_12 109 108 26
C3_121 109 117 6.42888e-17
C3_122 108 117 6.42888e-17
R3_13 99 108 104
C3_131 99 117 2.4644e-16
C3_132 108 117 2.4644e-16
R3_14 98 99 13
C3_141 98 117 5.3574e-17
C3_142 99 117 5.3574e-17
R1_1 119 118 15
R1_2 127 126 15
R1_3 129 126 15
R1_4 128 124 15
R1_5 125 124 15
R1_6 121 120 15
R1_7 123 122 15
R1_8 117 123 26
C1_81 117 117 6.42888e-17
C1_82 123 117 6.42888e-17
R1_9 117 121 26
C1_91 117 117 6.42888e-17
C1_92 121 117 6.42888e-17
R1_10 125 128 26
C1_101 125 117 7.50036e-17
C1_102 128 117 7.50036e-17
R1_11 117 125 26
C1_111 117 117 6.42888e-17
C1_112 125 117 6.42888e-17
R1_12 127 129 26
C1_121 127 117 7.50036e-17
C1_122 129 117 7.50036e-17
R1_13 117 127 26
C1_131 117 117 6.42888e-17
C1_132 127 117 6.42888e-17
R1_14 117 119 26
C1_141 117 117 6.42888e-17
C1_142 119 117 6.42888e-17
.ends noa2a2a23_x4
