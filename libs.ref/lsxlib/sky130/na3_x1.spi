* Spice description of na3_x1
* Spice driver version -1719579731
* Date ( dd/mm/yyyy hh:mm:ss ):  8/05/2026 at 14:23:17

* INTERF i0 i1 i2 nq vdd vss

.subckt na3_x1 8 15 20 31 5 26
* NET 5 = vdd
* NET 8 = i0
* NET 15 = i1
* NET 20 = i2
* NET 26 = vss
* NET 31 = nq
Mtr_00006 35 23 2 5 sky130_fd_pr__pfet_01v8__model L=0.15U W=1.26U AS=0.3654P AD=0.3654P PS=3.1U PD=3.1U
Mtr_00005 2 17 34 5 sky130_fd_pr__pfet_01v8__model L=0.15U W=1.26U AS=0.3654P AD=0.3654P PS=3.1U PD=3.1U
Mtr_00004 34 11 1 5 sky130_fd_pr__pfet_01v8__model L=0.15U W=1.26U AS=0.3654P AD=0.3654P PS=3.1U PD=3.1U
Mtr_00003 40 21 32 26 sky130_fd_pr__nfet_01v8__model L=0.15U W=1.62U AS=0.4698P AD=0.4698P PS=3.82U PD=3.82U
Mtr_00002 27 9 43 26 sky130_fd_pr__nfet_01v8__model L=0.15U W=1.62U AS=0.4698P AD=0.4698P PS=3.82U PD=3.82U
Mtr_00001 43 14 40 26 sky130_fd_pr__nfet_01v8__model L=0.15U W=1.62U AS=0.4698P AD=0.4698P PS=3.82U PD=3.82U
R8_1 4 2 15
R8_2 3 1 15
R8_3 3 5 26
C8_31 3 26 6.42888e-17
C8_32 5 26 6.42888e-17
R8_4 4 5 26
C8_41 4 26 6.42888e-17
C8_42 5 26 6.42888e-17
R7_1 10 8 15
R7_2 10 11 576
C7_21 10 26 9.98634e-17
C7_22 11 26 9.98634e-17
R7_3 9 10 528
C7_31 9 26 9.01992e-17
C7_32 10 26 9.01992e-17
R6_1 16 15 15
R6_2 16 17 576
C6_21 16 26 9.98634e-17
C6_22 17 26 9.98634e-17
R6_3 14 16 528
C6_31 14 26 9.01992e-17
C6_32 16 26 9.01992e-17
R5_1 22 20 15
R5_2 22 23 576
C5_21 22 26 9.98634e-17
C5_22 23 26 9.98634e-17
R5_3 21 22 528
C5_31 21 26 9.01992e-17
C5_32 22 26 9.01992e-17
R4_1 27 28 15
R4_2 26 28 26
C4_21 26 26 6.42888e-17
C4_22 28 26 6.42888e-17
R3_1 33 32 15
R3_2 31 34 7.5
R3_3 37 35 15
R3_4 36 37 13
C3_41 36 26 5.3574e-17
C3_42 37 26 5.3574e-17
R3_5 31 36 52
C3_51 31 26 1.28578e-16
C3_52 36 26 1.28578e-16
R3_6 31 33 52
C3_61 31 26 1.28578e-16
C3_62 33 26 1.28578e-16
.ends na3_x1
