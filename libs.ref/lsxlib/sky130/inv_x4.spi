* Spice description of inv_x4
* Spice driver version 436292525
* Date ( dd/mm/yyyy hh:mm:ss ):  8/05/2026 at 14:22:51

* INTERF i nq vdd vss

.subckt inv_x4 1 29 17 20
* NET 1 = i
* NET 17 = vdd
* NET 20 = vss
* NET 29 = nq
Mtr_00004 10 6 30 17 sky130_fd_pr__pfet_01v8__model L=0.15U W=2.46U AS=0.7134P AD=0.7134P PS=5.5U PD=5.5U
Mtr_00003 30 4 9 17 sky130_fd_pr__pfet_01v8__model L=0.15U W=2.46U AS=0.7134P AD=0.7134P PS=5.5U PD=5.5U
Mtr_00002 28 3 22 20 sky130_fd_pr__nfet_01v8__model L=0.15U W=1.26U AS=0.3654P AD=0.3654P PS=3.1U PD=3.1U
Mtr_00001 21 2 28 20 sky130_fd_pr__nfet_01v8__model L=0.15U W=1.26U AS=0.3654P AD=0.3654P PS=3.1U PD=3.1U
R4_1 5 1 15
R4_2 5 6 576
C4_21 5 20 9.98634e-17
C4_22 6 20 9.98634e-17
R4_3 3 5 384
C4_31 3 20 6.76494e-17
C4_32 5 20 6.76494e-17
R4_4 5 4 576
C4_41 5 20 9.98634e-17
C4_42 4 20 9.98634e-17
R4_5 2 5 384
C4_51 2 20 6.76494e-17
C4_52 5 20 6.76494e-17
R3_1 16 10 15
R3_2 12 10 15
R3_3 14 10 15
R3_4 10 11 15
R3_5 15 9 15
R3_6 13 9 15
R3_7 15 17 26
C3_71 15 20 6.42888e-17
C3_72 17 20 6.42888e-17
R3_8 13 15 13
C3_81 13 20 5.3574e-17
C3_82 15 20 5.3574e-17
R3_9 16 17 26
C3_91 16 20 6.42888e-17
C3_92 17 20 6.42888e-17
R3_10 14 16 13
C3_101 14 20 5.3574e-17
C3_102 16 20 5.3574e-17
R3_11 12 14 26
C3_111 12 20 6.42888e-17
C3_112 14 20 6.42888e-17
R3_12 11 12 26
C3_121 11 20 6.42888e-17
C3_122 12 20 6.42888e-17
R2_1 25 22 15
R2_2 24 22 15
R2_3 23 21 15
R2_4 20 23 26
C2_41 20 20 6.42888e-17
C2_42 23 20 6.42888e-17
R2_5 24 25 26
C2_51 24 20 7.50036e-17
C2_52 25 20 7.50036e-17
R2_6 20 24 26
C2_61 20 20 6.42888e-17
C2_62 24 20 6.42888e-17
R1_1 29 28 7.5
R1_2 29 30 3.75
.ends inv_x4
