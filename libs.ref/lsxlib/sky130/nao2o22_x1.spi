* Spice description of nao2o22_x1
* Spice driver version 1849621421
* Date ( dd/mm/yyyy hh:mm:ss ):  8/05/2026 at 14:23:17

* INTERF i0 i1 i2 i3 nq nq vdd vss

.subckt nao2o22_x1 19 14 9 2 39 40 35 54
* NET 2 = i3
* NET 9 = i2
* NET 14 = i1
* NET 19 = i0
* NET 35 = vdd
* NET 39 = nq
* NET 40 = nq
* NET 54 = vss
Mtr_00008 28 3 41 35 sky130_fd_pr__pfet_01v8__model L=0.15U W=2.46U AS=0.7134P AD=0.7134P PS=5.5U PD=5.5U
Mtr_00007 32 7 28 35 sky130_fd_pr__pfet_01v8__model L=0.15U W=2.46U AS=0.7134P AD=0.7134P PS=5.5U PD=5.5U
Mtr_00006 41 16 25 35 sky130_fd_pr__pfet_01v8__model L=0.15U W=2.46U AS=0.7134P AD=0.7134P PS=5.5U PD=5.5U
Mtr_00005 25 22 31 35 sky130_fd_pr__pfet_01v8__model L=0.15U W=2.46U AS=0.7134P AD=0.7134P PS=5.5U PD=5.5U
Mtr_00004 55 8 48 54 sky130_fd_pr__nfet_01v8__model L=0.15U W=1.26U AS=0.3654P AD=0.3654P PS=3.1U PD=3.1U
Mtr_00003 46 1 55 54 sky130_fd_pr__nfet_01v8__model L=0.15U W=1.26U AS=0.3654P AD=0.3654P PS=3.1U PD=3.1U
Mtr_00002 38 13 46 54 sky130_fd_pr__nfet_01v8__model L=0.15U W=1.26U AS=0.3654P AD=0.3654P PS=3.1U PD=3.1U
Mtr_00001 44 20 38 54 sky130_fd_pr__nfet_01v8__model L=0.15U W=1.26U AS=0.3654P AD=0.3654P PS=3.1U PD=3.1U
R10_1 4 2 15
R10_2 4 3 528
C10_21 4 54 9.34206e-17
C10_22 3 54 9.34206e-17
R10_3 1 4 432
C10_31 1 54 7.40922e-17
C10_32 4 54 7.40922e-17
R9_1 10 9 15
R9_2 10 7 528
C9_21 10 54 9.34206e-17
C9_22 7 54 9.34206e-17
R9_3 8 10 432
C9_31 8 54 7.40922e-17
C9_32 10 54 7.40922e-17
R8_1 15 14 15
R8_2 15 16 528
C8_21 15 54 9.34206e-17
C8_22 16 54 9.34206e-17
R8_3 13 15 432
C8_31 13 54 7.40922e-17
C8_32 15 54 7.40922e-17
R7_1 21 19 15
R7_2 21 22 528
C7_21 21 54 9.34206e-17
C7_22 22 54 9.34206e-17
R7_3 20 21 432
C7_31 20 54 7.40922e-17
C7_32 21 54 7.40922e-17
R4_1 34 32 15
R4_2 33 31 15
R4_3 33 35 26
C4_31 33 54 6.42888e-17
C4_32 35 54 6.42888e-17
R4_4 34 35 26
C4_41 34 54 6.42888e-17
C4_42 35 54 6.42888e-17
R3_1 39 38 15
R3_2 40 41 3.75
R3_3 39 40 26
C3_31 39 54 6.42888e-17
C3_32 40 54 6.42888e-17
R2_1 51 48 15
R2_2 49 48 15
R2_3 50 46 15
R2_4 47 46 15
R2_5 45 44 15
R2_6 45 47 52
C2_61 45 54 1.28578e-16
C2_62 47 54 1.28578e-16
R2_7 47 50 13
C2_71 47 54 5.3574e-17
C2_72 50 54 5.3574e-17
R2_8 49 51 13
C2_81 49 54 5.3574e-17
C2_82 51 54 5.3574e-17
R2_9 50 51 52
C2_91 50 54 1.28578e-16
C2_92 51 54 1.28578e-16
R1_1 56 55 15
R1_2 54 56 26
C1_21 54 54 6.42888e-17
C1_22 56 54 6.42888e-17
.ends nao2o22_x1
