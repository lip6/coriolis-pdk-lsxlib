* Spice description of nts_x2
* Spice driver version 341150637
* Date ( dd/mm/yyyy hh:mm:ss ):  8/05/2026 at 14:23:17

* INTERF cmd i nq vdd vss

.subckt nts_x2 1 11 39 32 54
* NET 1 = cmd
* NET 11 = i
* NET 32 = vdd
* NET 39 = nq
* NET 54 = vss
Mtr_00010 48 7 25 32 sky130_fd_pr__pfet_01v8__model L=0.15U W=1.26U AS=0.3654P AD=0.3654P PS=3.1U PD=3.1U
Mtr_00009 19 13 25 32 sky130_fd_pr__pfet_01v8__model L=0.15U W=2.34U AS=0.6786P AD=0.6786P PS=5.26U PD=5.26U
Mtr_00008 40 45 19 32 sky130_fd_pr__pfet_01v8__model L=0.15U W=2.34U AS=0.6786P AD=0.6786P PS=5.26U PD=5.26U
Mtr_00007 22 47 40 32 sky130_fd_pr__pfet_01v8__model L=0.15U W=2.34U AS=0.6786P AD=0.6786P PS=5.26U PD=5.26U
Mtr_00006 26 15 22 32 sky130_fd_pr__pfet_01v8__model L=0.15U W=2.34U AS=0.6786P AD=0.6786P PS=5.26U PD=5.26U
Mtr_00005 35 10 55 54 sky130_fd_pr__nfet_01v8__model L=0.15U W=1.14U AS=0.3306P AD=0.3306P PS=2.86U PD=2.86U
Mtr_00004 38 3 35 54 sky130_fd_pr__nfet_01v8__model L=0.15U W=1.14U AS=0.3306P AD=0.3306P PS=2.86U PD=2.86U
Mtr_00003 55 2 43 54 sky130_fd_pr__nfet_01v8__model L=0.15U W=0.66U AS=0.1914P AD=0.1914P PS=1.9U PD=1.9U
Mtr_00002 62 12 57 54 sky130_fd_pr__nfet_01v8__model L=0.15U W=1.14U AS=0.3306P AD=0.3306P PS=2.86U PD=2.86U
Mtr_00001 38 4 62 54 sky130_fd_pr__nfet_01v8__model L=0.15U W=1.14U AS=0.3306P AD=0.3306P PS=2.86U PD=2.86U
R10_1 3 6 15
R10_2 5 1 15
R10_3 5 7 912
C10_31 5 54 1.57849e-16
C10_32 7 54 1.57849e-16
R10_4 2 5 336
C10_41 2 54 5.79852e-17
C10_42 5 54 5.79852e-17
R10_5 1 6 26
C10_51 1 54 8.57184e-17
C10_52 6 54 8.57184e-17
R10_6 3 4 240
C10_61 3 54 4.42943e-17
C10_62 4 54 4.42943e-17
R9_1 16 11 15
R9_2 16 15 576
C9_21 16 54 1.03085e-16
C9_22 15 54 1.03085e-16
R9_3 12 16 384
C9_31 12 54 7.08708e-17
C9_32 16 54 7.08708e-17
R9_4 14 16 528
C9_41 14 54 9.4226e-17
C9_42 16 54 9.4226e-17
R9_5 14 13 576
C9_51 14 54 1.03085e-16
C9_52 13 54 1.03085e-16
R9_6 10 14 384
C9_61 10 54 7.08708e-17
C9_62 14 54 7.08708e-17
R6_1 30 25 5
R6_2 28 26 15
R6_3 29 26 15
R6_4 31 26 15
R6_5 27 26 15
R6_6 31 32 26
C6_61 31 54 6.42888e-17
C6_62 32 54 6.42888e-17
R6_7 29 31 13
C6_71 29 54 5.3574e-17
C6_72 31 54 5.3574e-17
R6_8 28 29 13
C6_81 28 54 5.3574e-17
C6_82 29 54 5.3574e-17
R6_9 27 28 13
C6_91 27 54 5.3574e-17
C6_92 28 54 5.3574e-17
R6_10 30 32 26
C6_101 30 54 6.42888e-17
C6_102 32 54 6.42888e-17
R4_1 39 38 7.5
R4_2 39 40 3.75
R3_1 44 43 15
R3_2 49 48 15
R3_3 51 48 15
R3_4 45 46 15
R3_5 45 47 240
C3_51 45 54 4.42943e-17
C3_52 47 54 4.42943e-17
R3_6 46 50 65
C3_61 46 54 1.60722e-16
C3_62 50 54 1.60722e-16
R3_7 49 50 52
C3_71 49 54 1.28578e-16
C3_72 50 54 1.28578e-16
R3_8 49 51 26
C3_81 49 54 6.42888e-17
C3_82 51 54 6.42888e-17
R3_9 44 49 143
C3_91 44 54 3.42874e-16
C3_92 49 54 3.42874e-16
R2_1 56 55 15
R2_2 59 57 15
R2_3 58 57 15
R2_4 58 59 13
C2_41 58 54 5.3574e-17
C2_42 59 54 5.3574e-17
R2_5 54 58 26
C2_51 54 54 6.42888e-17
C2_52 58 54 6.42888e-17
R2_6 54 56 26
C2_61 54 54 6.42888e-17
C2_62 56 54 6.42888e-17
.ends nts_x2
