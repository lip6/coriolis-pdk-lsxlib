* Spice description of oa2a22_x4
* Spice driver version -1934419
* Date ( dd/mm/yyyy hh:mm:ss ):  8/05/2026 at 14:22:51

* INTERF i0 i1 i2 i3 q vdd vss

.subckt oa2a22_x4 38 32 45 51 28 24 78
* NET 24 = vdd
* NET 28 = q
* NET 32 = i1
* NET 38 = i0
* NET 45 = i2
* NET 51 = i3
* NET 78 = vss
Mtr_00012 69 41 1 24 sky130_fd_pr__pfet_01v8__model L=0.15U W=1.74U AS=0.5046P AD=0.5046P PS=4.06U PD=4.06U
Mtr_00011 16 52 2 24 sky130_fd_pr__pfet_01v8__model L=0.15U W=1.74U AS=0.5046P AD=0.5046P PS=4.06U PD=4.06U
Mtr_00010 3 47 16 24 sky130_fd_pr__pfet_01v8__model L=0.15U W=1.74U AS=0.5046P AD=0.5046P PS=4.06U PD=4.06U
Mtr_00009 2 35 69 24 sky130_fd_pr__pfet_01v8__model L=0.15U W=1.74U AS=0.5046P AD=0.5046P PS=4.06U PD=4.06U
Mtr_00008 29 67 14 24 sky130_fd_pr__pfet_01v8__model L=0.15U W=2.46U AS=0.7134P AD=0.7134P PS=5.5U PD=5.5U
Mtr_00007 12 68 29 24 sky130_fd_pr__pfet_01v8__model L=0.15U W=2.46U AS=0.7134P AD=0.7134P PS=5.5U PD=5.5U
Mtr_00006 56 44 81 78 sky130_fd_pr__nfet_01v8__model L=0.15U W=0.9U AS=0.261P AD=0.261P PS=2.38U PD=2.38U
Mtr_00005 59 50 56 78 sky130_fd_pr__nfet_01v8__model L=0.15U W=0.9U AS=0.261P AD=0.261P PS=2.38U PD=2.38U
Mtr_00004 75 33 59 78 sky130_fd_pr__nfet_01v8__model L=0.15U W=0.9U AS=0.261P AD=0.261P PS=2.38U PD=2.38U
Mtr_00003 79 39 75 78 sky130_fd_pr__nfet_01v8__model L=0.15U W=0.9U AS=0.261P AD=0.261P PS=2.38U PD=2.38U
Mtr_00002 85 63 27 78 sky130_fd_pr__nfet_01v8__model L=0.15U W=1.26U AS=0.3654P AD=0.3654P PS=3.1U PD=3.1U
Mtr_00001 27 64 83 78 sky130_fd_pr__nfet_01v8__model L=0.15U W=1.26U AS=0.3654P AD=0.3654P PS=3.1U PD=3.1U
R11_1 8 2 15
R11_2 5 2 15
R11_3 7 1 15
R11_4 6 3 15
R11_5 4 1 15
R11_6 9 3 15
R11_7 6 9 13
C11_71 6 78 5.3574e-17
C11_72 9 78 5.3574e-17
R11_8 4 7 13
C11_81 4 78 5.3574e-17
C11_82 7 78 5.3574e-17
R11_9 5 6 52
C11_91 5 78 1.28578e-16
C11_92 6 78 1.28578e-16
R11_10 7 8 52
C11_101 7 78 1.28578e-16
C11_102 8 78 1.28578e-16
R11_11 5 8 13
C11_111 5 78 5.3574e-17
C11_112 8 78 5.3574e-17
R10_1 23 14 15
R10_2 20 14 15
R10_3 18 14 15
R10_4 14 15 15
R10_5 17 12 15
R10_6 22 12 15
R10_7 19 12 15
R10_8 13 12 15
R10_9 21 16 15
R10_10 21 24 26
C10_101 21 78 6.42888e-17
C10_102 24 78 6.42888e-17
R10_11 22 24 26
C10_111 22 78 6.42888e-17
C10_112 24 78 6.42888e-17
R10_12 19 22 26
C10_121 19 78 6.42888e-17
C10_122 22 78 6.42888e-17
R10_13 17 19 26
C10_131 17 78 6.42888e-17
C10_132 19 78 6.42888e-17
R10_14 13 17 13
C10_141 13 78 5.3574e-17
C10_142 17 78 5.3574e-17
R10_15 23 24 26
C10_151 23 78 6.42888e-17
C10_152 24 78 6.42888e-17
R10_16 20 23 26
C10_161 20 78 6.42888e-17
C10_162 23 78 6.42888e-17
R10_17 18 20 26
C10_171 18 78 6.42888e-17
C10_172 20 78 6.42888e-17
R10_18 15 18 13
C10_181 15 78 5.3574e-17
C10_182 18 78 5.3574e-17
R9_1 28 27 7.5
R9_2 28 29 3.75
R8_1 34 32 15
R8_2 34 35 672
C8_21 34 78 1.12749e-16
C8_22 35 78 1.12749e-16
R8_3 33 34 480
C8_31 33 78 8.37564e-17
C8_32 34 78 8.37564e-17
R7_1 40 38 15
R7_2 40 41 672
C7_21 40 78 1.12749e-16
C7_22 41 78 1.12749e-16
R7_3 39 40 480
C7_31 39 78 8.37564e-17
C7_32 40 78 8.37564e-17
R6_1 46 45 15
R6_2 46 47 672
C6_21 46 78 1.12749e-16
C6_22 47 78 1.12749e-16
R6_3 44 46 480
C6_31 44 78 8.37564e-17
C6_32 46 78 8.37564e-17
R5_1 53 51 15
R5_2 53 52 672
C5_21 53 78 1.12749e-16
C5_22 52 78 1.12749e-16
R5_3 50 53 480
C5_31 50 78 8.37564e-17
C5_32 53 78 8.37564e-17
R3_1 60 59 15
R3_2 72 69 15
R3_3 66 65 15
R3_4 66 68 528
C3_41 66 78 9.34206e-17
C3_42 68 78 9.34206e-17
R3_5 64 66 432
C3_51 64 78 7.40922e-17
C3_52 66 78 7.40922e-17
R3_6 66 67 528
C3_61 66 78 9.34206e-17
C3_62 67 78 9.34206e-17
R3_7 63 66 432
C3_71 63 78 7.40922e-17
C3_72 66 78 7.40922e-17
R3_8 62 65 39
C3_81 62 78 1.07148e-16
C3_82 65 78 1.07148e-16
R3_9 71 72 13
C3_91 71 78 5.3574e-17
C3_92 72 78 5.3574e-17
R3_10 61 62 65
C3_101 61 78 1.60722e-16
C3_102 62 78 1.60722e-16
R3_11 71 70 26
C3_111 71 78 6.42888e-17
C3_112 70 78 6.42888e-17
R3_12 61 70 104
C3_121 61 78 2.4644e-16
C3_122 70 78 2.4644e-16
R3_13 60 61 13
C3_131 60 78 5.3574e-17
C3_132 61 78 5.3574e-17
R1_1 80 79 15
R1_2 82 81 15
R1_3 87 83 15
R1_4 84 83 15
R1_5 86 85 15
R1_6 88 85 15
R1_7 86 88 26
C1_71 86 78 7.50036e-17
C1_72 88 78 7.50036e-17
R1_8 78 86 26
C1_81 78 78 6.42888e-17
C1_82 86 78 6.42888e-17
R1_9 84 87 26
C1_91 84 78 7.50036e-17
C1_92 87 78 7.50036e-17
R1_10 78 84 26
C1_101 78 78 6.42888e-17
C1_102 84 78 6.42888e-17
R1_11 78 82 26
C1_111 78 78 6.42888e-17
C1_112 82 78 6.42888e-17
R1_12 78 80 26
C1_121 78 78 6.42888e-17
C1_122 80 78 6.42888e-17
.ends oa2a22_x4
