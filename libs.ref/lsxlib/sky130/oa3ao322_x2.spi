* Spice description of oa3ao322_x2
* Spice driver version -874128467
* Date ( dd/mm/yyyy hh:mm:ss ):  8/05/2026 at 14:22:51

* INTERF i0 i1 i2 i3 i4 i5 i6 q vdd vss

.subckt oa3ao322_x2 61 55 49 2 20 14 8 98 72 102
* NET 2 = i3
* NET 8 = i6
* NET 14 = i5
* NET 20 = i4
* NET 49 = i2
* NET 55 = i1
* NET 61 = i0
* NET 72 = vdd
* NET 98 = q
* NET 102 = vss
Mtr_00016 99 87 67 72 sky130_fd_pr__pfet_01v8__model L=0.15U W=2.46U AS=0.7134P AD=0.7134P PS=5.5U PD=5.5U
Mtr_00015 25 15 31 72 sky130_fd_pr__pfet_01v8__model L=0.15U W=2.46U AS=0.7134P AD=0.7134P PS=5.5U PD=5.5U
Mtr_00014 25 21 28 72 sky130_fd_pr__pfet_01v8__model L=0.15U W=2.46U AS=0.7134P AD=0.7134P PS=5.5U PD=5.5U
Mtr_00013 67 64 32 72 sky130_fd_pr__pfet_01v8__model L=0.15U W=1.5U AS=0.435P AD=0.435P PS=3.58U PD=3.58U
Mtr_00012 32 58 68 72 sky130_fd_pr__pfet_01v8__model L=0.15U W=1.5U AS=0.435P AD=0.435P PS=3.58U PD=3.58U
Mtr_00011 68 52 33 72 sky130_fd_pr__pfet_01v8__model L=0.15U W=1.5U AS=0.435P AD=0.435P PS=3.58U PD=3.58U
Mtr_00010 33 10 90 72 sky130_fd_pr__pfet_01v8__model L=0.15U W=1.5U AS=0.435P AD=0.435P PS=3.58U PD=3.58U
Mtr_00009 28 3 90 72 sky130_fd_pr__pfet_01v8__model L=0.15U W=2.46U AS=0.7134P AD=0.7134P PS=5.5U PD=5.5U
Mtr_00008 103 81 97 102 sky130_fd_pr__nfet_01v8__model L=0.15U W=1.26U AS=0.3654P AD=0.3654P PS=3.1U PD=3.1U
Mtr_00007 82 50 75 102 sky130_fd_pr__nfet_01v8__model L=0.15U W=1.14U AS=0.3306P AD=0.3306P PS=2.86U PD=2.86U
Mtr_00006 43 19 105 102 sky130_fd_pr__nfet_01v8__model L=0.15U W=0.54U AS=0.1566P AD=0.1566P PS=1.66U PD=1.66U
Mtr_00005 75 56 78 102 sky130_fd_pr__nfet_01v8__model L=0.15U W=1.14U AS=0.3306P AD=0.3306P PS=2.86U PD=2.86U
Mtr_00004 78 62 103 102 sky130_fd_pr__nfet_01v8__model L=0.15U W=1.14U AS=0.3306P AD=0.3306P PS=2.86U PD=2.86U
Mtr_00003 105 1 41 102 sky130_fd_pr__nfet_01v8__model L=0.15U W=0.54U AS=0.1566P AD=0.1566P PS=1.66U PD=1.66U
Mtr_00002 41 7 82 102 sky130_fd_pr__nfet_01v8__model L=0.15U W=0.54U AS=0.1566P AD=0.1566P PS=1.66U PD=1.66U
Mtr_00001 107 13 43 102 sky130_fd_pr__nfet_01v8__model L=0.15U W=0.54U AS=0.1566P AD=0.1566P PS=1.66U PD=1.66U
R17_1 4 2 15
R17_2 4 3 528
C17_21 4 102 9.34206e-17
C17_22 3 102 9.34206e-17
R17_3 1 4 528
C17_31 1 102 9.10046e-17
C17_32 4 102 9.10046e-17
R16_1 9 8 15
R16_2 9 10 672
C16_21 9 102 1.19192e-16
C16_22 10 102 1.19192e-16
R16_3 7 9 528
C16_31 7 102 9.10046e-17
C16_32 9 102 9.10046e-17
R15_1 16 14 15
R15_2 16 15 528
C15_21 16 102 9.34206e-17
C15_22 15 102 9.34206e-17
R15_3 13 16 528
C15_31 13 102 9.34206e-17
C15_32 16 102 9.34206e-17
R14_1 22 20 15
R14_2 22 21 528
C14_21 22 102 9.34206e-17
C14_22 21 102 9.34206e-17
R14_3 19 22 528
C14_31 19 102 9.10046e-17
C14_32 22 102 9.10046e-17
R11_1 38 31 15
R11_2 37 33 15
R11_3 36 32 15
R11_4 34 36 13
C11_41 34 102 5.3574e-17
C11_42 36 102 5.3574e-17
R11_5 34 35 52
C11_51 34 102 1.28578e-16
C11_52 35 102 1.28578e-16
R11_6 35 37 13
C11_61 35 102 5.3574e-17
C11_62 37 102 5.3574e-17
R11_7 37 38 104
C11_71 37 102 2.4644e-16
C11_72 38 102 2.4644e-16
R10_1 42 41 15
R10_2 44 43 7.5
R10_3 44 46 13
C10_31 44 102 5.3574e-17
C10_32 46 102 5.3574e-17
R10_4 45 46 52
C10_41 45 102 1.28578e-16
C10_42 46 102 1.28578e-16
R10_5 42 45 13
C10_51 42 102 5.3574e-17
C10_52 45 102 5.3574e-17
R9_1 51 49 15
R9_2 51 52 672
C9_21 51 102 1.19192e-16
C9_22 52 102 1.19192e-16
R9_3 50 51 432
C9_31 50 102 7.73136e-17
C9_32 51 102 7.73136e-17
R8_1 57 55 15
R8_2 57 58 672
C8_21 57 102 1.19192e-16
C8_22 58 102 1.19192e-16
R8_3 56 57 432
C8_31 56 102 7.73136e-17
C8_32 57 102 7.73136e-17
R7_1 63 61 15
R7_2 63 64 672
C7_21 63 102 1.19192e-16
C7_22 64 102 1.19192e-16
R7_3 62 63 432
C7_31 62 102 7.73136e-17
C7_32 63 102 7.73136e-17
R6_1 67 69 15
R6_2 67 70 15
R6_3 71 68 15
R6_4 71 72 26
C6_41 71 102 6.42888e-17
C6_42 72 102 6.42888e-17
R6_5 70 72 26
C6_51 70 102 6.42888e-17
C6_52 72 102 6.42888e-17
R6_6 69 70 13
C6_61 69 102 5.3574e-17
C6_62 70 102 5.3574e-17
R3_1 83 82 15
R3_2 84 82 15
R3_3 94 90 15
R3_4 91 90 15
R3_5 92 90 15
R3_6 89 88 15
R3_7 89 87 528
C3_71 89 102 9.34206e-17
C3_72 87 102 9.34206e-17
R3_8 81 89 432
C3_81 81 102 7.40922e-17
C3_82 89 102 7.40922e-17
R3_9 88 93 52
C3_91 88 102 1.39292e-16
C3_92 93 102 1.39292e-16
R3_10 93 91 117
C3_101 93 102 2.893e-16
C3_102 91 102 2.893e-16
R3_11 91 94 26
C3_111 91 102 5.89314e-17
C3_112 94 102 5.89314e-17
R3_12 92 91 26
C3_121 92 102 6.96462e-17
C3_122 91 102 6.96462e-17
R3_13 86 92 52
C3_131 86 102 1.17863e-16
C3_132 92 102 1.17863e-16
R3_14 85 86 26
C3_141 85 102 7.50036e-17
C3_142 86 102 7.50036e-17
R3_15 84 85 13
C3_151 84 102 4.28592e-17
C3_152 85 102 4.28592e-17
R3_16 83 84 26
C3_161 83 102 6.42888e-17
C3_162 84 102 6.42888e-17
R2_1 98 97 7.5
R2_2 98 99 3.75
R1_1 103 104 15
R1_2 106 105 15
R1_3 108 107 15
R1_4 102 108 26
C1_41 102 102 6.42888e-17
C1_42 108 102 6.42888e-17
R1_5 102 106 26
C1_51 102 102 6.42888e-17
C1_52 106 102 6.42888e-17
R1_6 102 104 26
C1_61 102 102 6.42888e-17
C1_62 104 102 6.42888e-17
.ends oa3ao322_x2
