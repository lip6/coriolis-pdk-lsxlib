* Spice description of nao2o22_x4
* Spice driver version 1048984493
* Date ( dd/mm/yyyy hh:mm:ss ):  8/05/2026 at 14:22:51

* INTERF i0 i1 i2 i3 nq vdd vss

.subckt nao2o22_x4 49 56 44 62 25 21 67
* NET 21 = vdd
* NET 25 = nq
* NET 44 = i2
* NET 49 = i0
* NET 56 = i1
* NET 62 = i3
* NET 67 = vss
Mtr_00014 38 87 7 21 sky130_fd_pr__pfet_01v8__model L=0.15U W=1.26U AS=0.3654P AD=0.3654P PS=3.1U PD=3.1U
Mtr_00013 26 37 9 21 sky130_fd_pr__pfet_01v8__model L=0.15U W=2.46U AS=0.7134P AD=0.7134P PS=5.5U PD=5.5U
Mtr_00012 7 36 26 21 sky130_fd_pr__pfet_01v8__model L=0.15U W=2.46U AS=0.7134P AD=0.7134P PS=5.5U PD=5.5U
Mtr_00011 1 52 13 21 sky130_fd_pr__pfet_01v8__model L=0.15U W=1.26U AS=0.3654P AD=0.3654P PS=3.1U PD=3.1U
Mtr_00010 4 64 85 21 sky130_fd_pr__pfet_01v8__model L=0.15U W=1.26U AS=0.3654P AD=0.3654P PS=3.1U PD=3.1U
Mtr_00009 14 46 4 21 sky130_fd_pr__pfet_01v8__model L=0.15U W=1.26U AS=0.3654P AD=0.3654P PS=3.1U PD=3.1U
Mtr_00008 85 58 1 21 sky130_fd_pr__pfet_01v8__model L=0.15U W=1.26U AS=0.3654P AD=0.3654P PS=3.1U PD=3.1U
Mtr_00007 70 80 29 67 sky130_fd_pr__nfet_01v8__model L=0.15U W=0.66U AS=0.1914P AD=0.1914P PS=1.9U PD=1.9U
Mtr_00006 24 31 70 67 sky130_fd_pr__nfet_01v8__model L=0.15U W=1.26U AS=0.3654P AD=0.3654P PS=3.1U PD=3.1U
Mtr_00005 72 32 24 67 sky130_fd_pr__nfet_01v8__model L=0.15U W=1.26U AS=0.3654P AD=0.3654P PS=3.1U PD=3.1U
Mtr_00004 68 43 95 67 sky130_fd_pr__nfet_01v8__model L=0.15U W=0.66U AS=0.1914P AD=0.1914P PS=1.9U PD=1.9U
Mtr_00003 93 61 68 67 sky130_fd_pr__nfet_01v8__model L=0.15U W=0.66U AS=0.1914P AD=0.1914P PS=1.9U PD=1.9U
Mtr_00002 78 55 93 67 sky130_fd_pr__nfet_01v8__model L=0.15U W=0.66U AS=0.1914P AD=0.1914P PS=1.9U PD=1.9U
Mtr_00001 91 50 78 67 sky130_fd_pr__nfet_01v8__model L=0.15U W=0.66U AS=0.1914P AD=0.1914P PS=1.9U PD=1.9U
R10_1 12 9 15
R10_2 16 9 15
R10_3 20 9 15
R10_4 9 10 15
R10_5 18 14 15
R10_6 15 7 15
R10_7 11 7 15
R10_8 19 7 15
R10_9 8 7 15
R10_10 17 13 15
R10_11 17 21 26
C10_111 17 67 6.42888e-17
C10_112 21 67 6.42888e-17
R10_12 19 21 26
C10_121 19 67 6.42888e-17
C10_122 21 67 6.42888e-17
R10_13 15 19 26
C10_131 15 67 6.42888e-17
C10_132 19 67 6.42888e-17
R10_14 11 15 26
C10_141 11 67 6.42888e-17
C10_142 15 67 6.42888e-17
R10_15 8 11 13
C10_151 8 67 5.3574e-17
C10_152 11 67 5.3574e-17
R10_16 18 21 26
C10_161 18 67 6.42888e-17
C10_162 21 67 6.42888e-17
R10_17 20 21 26
C10_171 20 67 6.42888e-17
C10_172 21 67 6.42888e-17
R10_18 16 20 26
C10_181 16 67 6.42888e-17
C10_182 20 67 6.42888e-17
R10_19 12 16 26
C10_191 12 67 6.42888e-17
C10_192 16 67 6.42888e-17
R10_20 10 12 13
C10_201 10 67 5.3574e-17
C10_202 12 67 5.3574e-17
R9_1 25 24 7.5
R9_2 25 26 3.75
R8_1 30 29 15
R8_2 39 38 15
R8_3 40 38 15
R8_4 35 34 15
R8_5 35 37 528
C8_51 35 67 9.34206e-17
C8_52 37 67 9.34206e-17
R8_6 32 35 432
C8_61 32 67 7.40922e-17
C8_62 35 67 7.40922e-17
R8_7 35 36 528
C8_71 35 67 9.34206e-17
C8_72 36 67 9.34206e-17
R8_8 31 35 432
C8_81 31 67 7.40922e-17
C8_82 35 67 7.40922e-17
R8_9 33 34 26
C8_91 33 67 7.50036e-17
C8_92 34 67 7.50036e-17
R8_10 39 40 26
C8_101 39 67 7.50036e-17
C8_102 40 67 7.50036e-17
R8_11 33 39 65
C8_111 33 67 1.71437e-16
C8_112 39 67 1.71437e-16
R8_12 30 33 65
C8_121 30 67 1.60722e-16
C8_122 33 67 1.60722e-16
R7_1 45 44 15
R7_2 45 46 720
C7_21 45 67 1.25635e-16
C7_22 46 67 1.25635e-16
R7_3 43 45 528
C7_31 43 67 9.01992e-17
C7_32 45 67 9.01992e-17
R6_1 51 49 15
R6_2 51 52 720
C6_21 51 67 1.25635e-16
C6_22 52 67 1.25635e-16
R6_3 50 51 528
C6_31 50 67 9.01992e-17
C6_32 51 67 9.01992e-17
R5_1 57 56 15
R5_2 57 58 720
C5_21 57 67 1.25635e-16
C5_22 58 67 1.25635e-16
R5_3 55 57 528
C5_31 55 67 9.01992e-17
C5_32 57 67 9.01992e-17
R4_1 63 62 15
R4_2 63 64 720
C4_21 63 67 1.25635e-16
C4_22 64 67 1.25635e-16
R4_3 61 63 528
C4_31 61 67 9.01992e-17
C4_32 63 67 9.01992e-17
R3_1 69 68 15
R3_2 73 72 15
R3_3 75 72 15
R3_4 71 70 15
R3_5 74 70 15
R3_6 71 74 26
C3_61 71 67 7.50036e-17
C3_62 74 67 7.50036e-17
R3_7 67 71 26
C3_71 67 67 6.42888e-17
C3_72 71 67 6.42888e-17
R3_8 73 75 26
C3_81 73 67 7.50036e-17
C3_82 75 67 7.50036e-17
R3_9 67 73 26
C3_91 67 67 6.42888e-17
C3_92 73 67 6.42888e-17
R3_10 67 69 26
C3_101 67 67 6.42888e-17
C3_102 69 67 6.42888e-17
R2_1 79 78 15
R2_2 84 83 15
R2_3 88 85 15
R2_4 86 85 15
R2_5 84 87 912
C2_51 84 67 1.57849e-16
C2_52 87 67 1.57849e-16
R2_6 80 84 336
C2_61 80 67 5.79852e-17
C2_62 84 67 5.79852e-17
R2_7 86 88 26
C2_71 86 67 6.42888e-17
C2_72 88 67 6.42888e-17
R2_8 82 86 104
C2_81 82 67 2.35726e-16
C2_82 86 67 2.35726e-16
R2_9 82 83 52
C2_91 82 67 1.39292e-16
C2_92 83 67 1.39292e-16
R2_10 81 82 26
C2_101 81 67 6.42888e-17
C2_102 82 67 6.42888e-17
R2_11 79 81 13
C2_111 79 67 5.3574e-17
C2_112 81 67 5.3574e-17
R1_1 96 95 15
R1_2 94 93 15
R1_3 92 91 15
R1_4 92 94 52
C1_41 92 67 1.28578e-16
C1_42 94 67 1.28578e-16
R1_5 94 97 13
C1_51 94 67 5.3574e-17
C1_52 97 67 5.3574e-17
R1_6 97 98 52
C1_61 97 67 1.28578e-16
C1_62 98 67 1.28578e-16
R1_7 96 98 13
C1_71 96 67 5.3574e-17
C1_72 98 67 5.3574e-17
.ends nao2o22_x4
