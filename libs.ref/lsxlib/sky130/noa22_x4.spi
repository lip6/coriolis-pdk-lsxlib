* Spice description of noa22_x4
* Spice driver version -1892811859
* Date ( dd/mm/yyyy hh:mm:ss ):  8/05/2026 at 14:22:51

* INTERF i0 i1 i2 nq vdd vss

.subckt noa22_x4 22 34 28 67 47 74
* NET 22 = i0
* NET 28 = i2
* NET 34 = i1
* NET 47 = vdd
* NET 67 = nq
* NET 74 = vss
Mtr_00012 41 62 17 47 sky130_fd_pr__pfet_01v8__model L=0.15U W=1.26U AS=0.3654P AD=0.3654P PS=3.1U PD=3.1U
Mtr_00011 40 31 2 47 sky130_fd_pr__pfet_01v8__model L=0.15U W=1.26U AS=0.3654P AD=0.3654P PS=3.1U PD=3.1U
Mtr_00010 59 25 1 47 sky130_fd_pr__pfet_01v8__model L=0.15U W=1.26U AS=0.3654P AD=0.3654P PS=3.1U PD=3.1U
Mtr_00009 2 37 59 47 sky130_fd_pr__pfet_01v8__model L=0.15U W=1.26U AS=0.3654P AD=0.3654P PS=3.1U PD=3.1U
Mtr_00008 40 13 68 47 sky130_fd_pr__pfet_01v8__model L=0.15U W=2.46U AS=0.7134P AD=0.7134P PS=5.5U PD=5.5U
Mtr_00007 68 14 41 47 sky130_fd_pr__pfet_01v8__model L=0.15U W=2.46U AS=0.7134P AD=0.7134P PS=5.5U PD=5.5U
Mtr_00006 9 54 79 74 sky130_fd_pr__nfet_01v8__model L=0.15U W=0.66U AS=0.1914P AD=0.1914P PS=1.9U PD=1.9U
Mtr_00005 50 29 77 74 sky130_fd_pr__nfet_01v8__model L=0.15U W=0.66U AS=0.1914P AD=0.1914P PS=1.9U PD=1.9U
Mtr_00004 71 35 50 74 sky130_fd_pr__nfet_01v8__model L=0.15U W=0.66U AS=0.1914P AD=0.1914P PS=1.9U PD=1.9U
Mtr_00003 75 23 71 74 sky130_fd_pr__nfet_01v8__model L=0.15U W=0.66U AS=0.1914P AD=0.1914P PS=1.9U PD=1.9U
Mtr_00002 79 8 66 74 sky130_fd_pr__nfet_01v8__model L=0.15U W=1.26U AS=0.3654P AD=0.3654P PS=3.1U PD=3.1U
Mtr_00001 66 7 77 74 sky130_fd_pr__nfet_01v8__model L=0.15U W=1.26U AS=0.3654P AD=0.3654P PS=3.1U PD=3.1U
R10_1 3 1 15
R10_2 4 2 15
R10_3 3 4 52
C10_31 3 74 1.28578e-16
C10_32 4 74 1.28578e-16
R9_1 12 11 15
R9_2 19 17 15
R9_3 18 17 15
R9_4 10 9 15
R9_5 16 15 15
R9_6 14 16 288
C9_61 14 74 5.15424e-17
C9_62 16 74 5.15424e-17
R9_7 13 14 192
C9_71 13 74 3.86568e-17
C9_72 14 74 3.86568e-17
R9_8 18 19 26
C9_81 18 74 7.50036e-17
C9_82 19 74 7.50036e-17
R9_9 15 18 52
C9_91 15 74 1.39292e-16
C9_92 18 74 1.39292e-16
R9_10 11 15 26
C9_101 11 74 8.57184e-17
C9_102 15 74 8.57184e-17
R9_11 10 11 39
C9_111 10 74 1.07148e-16
C9_112 11 74 1.07148e-16
R9_12 8 12 288
C9_121 8 74 5.15424e-17
C9_122 12 74 5.15424e-17
R9_13 7 8 192
C9_131 7 74 3.86568e-17
C9_132 8 74 3.86568e-17
R8_1 24 22 15
R8_2 24 25 768
C8_21 24 74 1.32077e-16
C8_22 25 74 1.32077e-16
R8_3 23 24 480
C8_31 23 74 8.37564e-17
C8_32 24 74 8.37564e-17
R7_1 30 28 15
R7_2 30 31 768
C7_21 30 74 1.32077e-16
C7_22 31 74 1.32077e-16
R7_3 29 30 480
C7_31 29 74 8.37564e-17
C7_32 30 74 8.37564e-17
R6_1 36 34 15
R6_2 36 37 768
C6_21 36 74 1.32077e-16
C6_22 37 74 1.32077e-16
R6_3 35 36 480
C6_31 35 74 8.37564e-17
C6_32 36 74 8.37564e-17
R5_1 45 40 15
R5_2 44 41 15
R5_3 43 41 15
R5_4 46 41 15
R5_5 42 41 15
R5_6 46 47 26
C5_61 46 74 6.42888e-17
C5_62 47 74 6.42888e-17
R5_7 44 46 26
C5_71 44 74 6.42888e-17
C5_72 46 74 6.42888e-17
R5_8 43 44 26
C5_81 43 74 6.42888e-17
C5_82 44 74 6.42888e-17
R5_9 42 43 13
C5_91 42 74 5.3574e-17
C5_92 43 74 5.3574e-17
R5_10 45 47 26
C5_101 45 74 6.42888e-17
C5_102 47 74 6.42888e-17
R4_1 51 50 15
R4_2 57 56 15
R4_3 60 59 15
R4_4 54 55 192
C4_41 54 74 3.86568e-17
C4_42 55 74 3.86568e-17
R4_5 62 63 192
C4_51 62 74 3.86568e-17
C4_52 63 74 3.86568e-17
R4_6 58 63 528
C4_61 58 74 9.01992e-17
C4_62 63 74 9.01992e-17
R4_7 55 58 336
C4_71 55 74 5.79852e-17
C4_72 58 74 5.79852e-17
R4_8 57 58 768
C4_81 57 74 1.28856e-16
C4_82 58 74 1.28856e-16
R4_9 60 61 52
C4_91 60 74 1.39292e-16
C4_92 61 74 1.39292e-16
R4_10 56 61 78
C4_101 56 74 2.03581e-16
C4_102 61 74 2.03581e-16
R4_11 53 56 39
C4_111 53 74 9.64332e-17
C4_112 56 74 9.64332e-17
R4_12 52 53 26
C4_121 52 74 7.50036e-17
C4_122 53 74 7.50036e-17
R4_13 51 52 13
C4_131 51 74 5.3574e-17
C4_132 52 74 5.3574e-17
R3_1 66 67 7.5
R3_2 67 68 3.75
R1_1 78 77 15
R1_2 81 79 15
R1_3 80 79 15
R1_4 76 75 15
R1_5 74 76 26
C1_51 74 74 6.42888e-17
C1_52 76 74 6.42888e-17
R1_6 80 81 26
C1_61 80 74 7.50036e-17
C1_62 81 74 7.50036e-17
R1_7 74 80 26
C1_71 74 74 6.42888e-17
C1_72 80 74 6.42888e-17
R1_8 74 78 26
C1_81 74 74 6.42888e-17
C1_82 78 74 6.42888e-17
.ends noa22_x4
