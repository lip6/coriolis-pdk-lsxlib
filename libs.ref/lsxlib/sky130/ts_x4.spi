* Spice description of ts_x4
* Spice driver version -1265521747
* Date ( dd/mm/yyyy hh:mm:ss ):  8/05/2026 at 14:22:52

* INTERF cmd i q vdd vss

.subckt ts_x4 9 2 87 49 91
* NET 2 = i
* NET 9 = cmd
* NET 49 = vdd
* NET 87 = q
* NET 91 = vss
Mtr_00012 59 20 42 49 sky130_fd_pr__pfet_01v8__model L=0.15U W=1.26U AS=0.3654P AD=0.3654P PS=3.1U PD=3.1U
Mtr_00011 32 64 81 49 sky130_fd_pr__pfet_01v8__model L=0.15U W=1.26U AS=0.3654P AD=0.3654P PS=3.1U PD=3.1U
Mtr_00010 42 26 88 49 sky130_fd_pr__pfet_01v8__model L=0.15U W=2.46U AS=0.7134P AD=0.7134P PS=5.5U PD=5.5U
Mtr_00009 88 27 40 49 sky130_fd_pr__pfet_01v8__model L=0.15U W=2.46U AS=0.7134P AD=0.7134P PS=5.5U PD=5.5U
Mtr_00008 45 21 32 49 sky130_fd_pr__pfet_01v8__model L=0.15U W=1.26U AS=0.3654P AD=0.3654P PS=3.1U PD=3.1U
Mtr_00007 34 5 45 49 sky130_fd_pr__pfet_01v8__model L=0.15U W=1.26U AS=0.3654P AD=0.3654P PS=3.1U PD=3.1U
Mtr_00006 96 57 71 91 sky130_fd_pr__nfet_01v8__model L=0.15U W=0.66U AS=0.1914P AD=0.1914P PS=1.9U PD=1.9U
Mtr_00005 24 12 74 91 sky130_fd_pr__nfet_01v8__model L=0.15U W=0.66U AS=0.1914P AD=0.1914P PS=1.9U PD=1.9U
Mtr_00004 86 70 92 91 sky130_fd_pr__nfet_01v8__model L=0.15U W=1.26U AS=0.3654P AD=0.3654P PS=3.1U PD=3.1U
Mtr_00003 94 69 86 91 sky130_fd_pr__nfet_01v8__model L=0.15U W=1.26U AS=0.3654P AD=0.3654P PS=3.1U PD=3.1U
Mtr_00002 52 8 94 91 sky130_fd_pr__nfet_01v8__model L=0.15U W=0.66U AS=0.1914P AD=0.1914P PS=1.9U PD=1.9U
Mtr_00001 74 1 96 91 sky130_fd_pr__nfet_01v8__model L=0.15U W=0.66U AS=0.1914P AD=0.1914P PS=1.9U PD=1.9U
R8_1 3 2 15
R8_2 4 2 15
R8_3 4 5 432
C8_31 4 91 7.40922e-17
C8_32 5 91 7.40922e-17
R8_4 1 3 336
C8_41 1 91 5.79852e-17
C8_42 3 91 5.79852e-17
R7_1 11 10 15
R7_2 17 16 15
R7_3 19 18 15
R7_4 14 13 15
R7_5 12 15 480
C7_51 12 91 8.37564e-17
C7_52 15 91 8.37564e-17
R7_6 14 15 384
C7_61 14 91 6.4428e-17
C7_62 15 91 6.4428e-17
R7_7 13 18 39
C7_71 13 91 1.07148e-16
C7_72 18 91 1.07148e-16
R7_8 19 21 432
C7_81 19 91 7.40922e-17
C7_82 21 91 7.40922e-17
R7_9 17 20 432
C7_91 17 91 7.40922e-17
C7_92 20 91 7.40922e-17
R7_10 17 19 624
C7_101 17 91 1.07917e-16
C7_102 19 91 1.07917e-16
R7_11 9 16 13
C7_111 9 91 4.28592e-17
C7_112 16 91 4.28592e-17
R7_12 9 10 13
C7_121 9 91 4.28592e-17
C7_122 10 91 4.28592e-17
R7_13 8 11 192
C7_131 8 91 3.86568e-17
C7_132 11 91 3.86568e-17
R6_1 31 30 15
R6_2 35 34 15
R6_3 37 34 15
R6_4 25 24 15
R6_5 33 32 15
R6_6 36 32 15
R6_7 33 36 26
C6_71 33 91 6.42888e-17
C6_72 36 91 6.42888e-17
R6_8 33 35 52
C6_81 33 91 1.28578e-16
C6_82 35 91 1.28578e-16
R6_9 35 37 26
C6_91 35 91 6.42888e-17
C6_92 37 91 6.42888e-17
R6_10 30 35 65
C6_101 30 91 1.50007e-16
C6_102 35 91 1.50007e-16
R6_11 25 30 78
C6_111 25 91 1.92866e-16
C6_112 30 91 1.92866e-16
R6_12 28 31 336
C6_121 28 91 1.15096e-16
C6_122 31 91 1.15096e-16
R6_13 29 28 0.001
C6_131 29 91 1.53128e-17
C6_132 28 91 1.53128e-17
R6_14 26 29 288
C6_141 26 91 1.01848e-16
C6_142 29 91 1.01848e-16
R6_15 27 26 96
C6_151 27 91 3.97454e-17
C6_152 26 91 3.97454e-17
R5_1 41 40 15
R5_2 44 40 15
R5_3 43 40 15
R5_4 46 40 15
R5_5 48 45 15
R5_6 47 42 15
R5_7 47 49 26
C5_71 47 91 6.42888e-17
C5_72 49 91 6.42888e-17
R5_8 48 49 26
C5_81 48 91 6.42888e-17
C5_82 49 91 6.42888e-17
R5_9 46 49 26
C5_91 46 91 6.42888e-17
C5_92 49 91 6.42888e-17
R5_10 44 46 26
C5_101 44 91 6.42888e-17
C5_102 46 91 6.42888e-17
R5_11 43 44 13
C5_111 43 91 5.3574e-17
C5_112 44 91 5.3574e-17
R5_12 41 43 13
C5_121 41 91 5.3574e-17
C5_122 43 91 5.3574e-17
R4_1 53 52 15
R4_2 62 61 15
R4_3 56 55 15
R4_4 60 59 15
R4_5 66 59 15
R4_6 57 58 192
C4_61 57 91 3.86568e-17
C4_62 58 91 3.86568e-17
R4_7 65 64 288
C4_71 65 91 4.8321e-17
C4_72 64 91 4.8321e-17
R4_8 56 58 288
C4_81 56 91 5.15424e-17
C4_82 58 91 5.15424e-17
R4_9 60 66 26
C4_91 60 91 7.50036e-17
C4_92 66 91 7.50036e-17
R4_10 62 65 288
C4_101 62 91 5.15424e-17
C4_102 65 91 5.15424e-17
R4_11 60 63 13
C4_111 60 91 3.21444e-17
C4_112 63 91 3.21444e-17
R4_12 61 63 13
C4_121 61 91 4.28592e-17
C4_122 63 91 4.28592e-17
R4_13 55 61 91
C4_131 55 91 2.14296e-16
C4_132 61 91 2.14296e-16
R4_14 54 55 26
C4_141 54 91 7.50036e-17
C4_142 55 91 7.50036e-17
R4_15 53 54 13
C4_151 53 91 3.21444e-17
C4_152 54 91 3.21444e-17
R3_1 72 71 15
R3_2 83 81 15
R3_3 82 81 15
R3_4 80 79 15
R3_5 76 74 15
R3_6 70 77 288
C3_61 70 91 5.47638e-17
C3_62 77 91 5.47638e-17
R3_7 69 78 288
C3_71 69 91 5.47638e-17
C3_72 78 91 5.47638e-17
R3_8 76 75 13
C3_81 76 91 5.3574e-17
C3_82 75 91 5.3574e-17
R3_9 78 80 336
C3_91 78 91 1.12612e-16
C3_92 80 91 1.12612e-16
R3_10 77 78 96
C3_101 77 91 3.97454e-17
C3_102 78 91 3.97454e-17
R3_11 73 75 52
C3_111 73 91 1.28578e-16
C3_112 75 91 1.28578e-16
R3_12 82 83 26
C3_121 82 91 7.50036e-17
C3_122 83 91 7.50036e-17
R3_13 79 82 78
C3_131 79 91 2.03581e-16
C3_132 82 91 2.03581e-16
R3_14 73 79 26
C3_141 73 91 7.50036e-17
C3_142 79 91 7.50036e-17
R3_15 72 73 13
C3_151 72 91 5.3574e-17
C3_152 73 91 5.3574e-17
R2_1 87 86 7.5
R2_2 87 88 3.75
R1_1 95 94 15
R1_2 97 96 15
R1_3 98 92 15
R1_4 93 92 15
R1_5 93 98 26
C1_51 93 91 6.42888e-17
C1_52 98 91 6.42888e-17
R1_6 91 93 26
C1_61 91 91 6.42888e-17
C1_62 93 91 6.42888e-17
R1_7 91 97 26
C1_71 91 91 6.42888e-17
C1_72 97 91 6.42888e-17
R1_8 91 95 26
C1_81 91 91 6.42888e-17
C1_82 95 91 6.42888e-17
.ends ts_x4
