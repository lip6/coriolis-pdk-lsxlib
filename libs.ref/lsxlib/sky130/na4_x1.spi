* Spice description of na4_x1
* Spice driver version 689036205
* Date ( dd/mm/yyyy hh:mm:ss ):  8/05/2026 at 14:23:17

* INTERF i0 i1 i2 i3 nq vdd vss

.subckt na4_x1 9 26 21 15 39 5 32
* NET 5 = vdd
* NET 9 = i0
* NET 15 = i3
* NET 21 = i2
* NET 26 = i1
* NET 32 = vss
* NET 39 = nq
Mtr_00008 44 29 1 5 sky130_fd_pr__pfet_01v8__model L=0.15U W=0.9U AS=0.261P AD=0.261P PS=2.38U PD=2.38U
Mtr_00007 2 23 44 5 sky130_fd_pr__pfet_01v8__model L=0.15U W=0.9U AS=0.261P AD=0.261P PS=2.38U PD=2.38U
Mtr_00006 45 17 2 5 sky130_fd_pr__pfet_01v8__model L=0.15U W=0.9U AS=0.261P AD=0.261P PS=2.38U PD=2.38U
Mtr_00005 42 11 1 5 sky130_fd_pr__pfet_01v8__model L=0.15U W=0.9U AS=0.261P AD=0.261P PS=2.38U PD=2.38U
Mtr_00004 33 8 51 32 sky130_fd_pr__nfet_01v8__model L=0.15U W=1.62U AS=0.4698P AD=0.4698P PS=3.82U PD=3.82U
Mtr_00003 54 14 40 32 sky130_fd_pr__nfet_01v8__model L=0.15U W=1.62U AS=0.4698P AD=0.4698P PS=3.82U PD=3.82U
Mtr_00002 51 27 57 32 sky130_fd_pr__nfet_01v8__model L=0.15U W=1.62U AS=0.4698P AD=0.4698P PS=3.82U PD=3.82U
Mtr_00001 57 20 54 32 sky130_fd_pr__nfet_01v8__model L=0.15U W=1.62U AS=0.4698P AD=0.4698P PS=3.82U PD=3.82U
R10_1 3 1 15
R10_2 4 2 15
R10_3 4 5 26
C10_31 4 32 6.42888e-17
C10_32 5 32 6.42888e-17
R10_4 3 5 26
C10_41 3 32 6.42888e-17
C10_42 5 32 6.42888e-17
R9_1 10 9 15
R9_2 10 11 624
C9_21 10 32 1.09528e-16
C9_22 11 32 1.09528e-16
R9_3 8 10 528
C9_31 8 32 9.01992e-17
C9_32 10 32 9.01992e-17
R8_1 16 15 15
R8_2 16 17 624
C8_21 16 32 1.09528e-16
C8_22 17 32 1.09528e-16
R8_3 14 16 528
C8_31 14 32 9.01992e-17
C8_32 16 32 9.01992e-17
R7_1 22 21 15
R7_2 22 23 624
C7_21 22 32 1.09528e-16
C7_22 23 32 1.09528e-16
R7_3 20 22 528
C7_31 20 32 9.01992e-17
C7_32 22 32 9.01992e-17
R6_1 28 26 15
R6_2 28 29 624
C6_21 28 32 1.09528e-16
C6_22 29 32 1.09528e-16
R6_3 27 28 528
C6_31 27 32 9.01992e-17
C6_32 28 32 9.01992e-17
R5_1 34 33 15
R5_2 36 33 15
R5_3 35 33 15
R5_4 35 36 13
C5_41 35 32 5.3574e-17
C5_42 36 32 5.3574e-17
R5_5 34 35 13
C5_51 34 32 5.3574e-17
C5_52 35 32 5.3574e-17
R5_6 32 34 26
C5_61 32 32 6.42888e-17
C5_62 34 32 6.42888e-17
R4_1 41 40 15
R4_2 39 44 7.5
R4_3 46 45 15
R4_4 43 42 15
R4_5 48 45 15
R4_6 47 42 15
R4_7 43 47 13
C4_71 43 32 4.82166e-17
C4_72 47 32 4.82166e-17
R4_8 46 48 13
C4_81 46 32 4.82166e-17
C4_82 48 32 4.82166e-17
R4_9 39 46 52
C4_91 39 32 1.28578e-16
C4_92 46 32 1.28578e-16
R4_10 43 39 52
C4_101 43 32 1.28578e-16
C4_102 39 32 1.28578e-16
R4_11 39 41 52
C4_111 39 32 1.28578e-16
C4_112 41 32 1.28578e-16
.ends na4_x1
