* Spice description of na2_x4
* Spice driver version 1972825005
* Date ( dd/mm/yyyy hh:mm:ss ):  8/05/2026 at 14:22:51

* INTERF i0 i1 nq vdd vss

.subckt na2_x4 16 25 65 42 69
* NET 16 = i0
* NET 25 = i1
* NET 42 = vdd
* NET 65 = nq
* NET 69 = vss
Mtr_00010 33 59 11 42 sky130_fd_pr__pfet_01v8__model L=0.15U W=1.26U AS=0.3654P AD=0.3654P PS=3.1U PD=3.1U
Mtr_00009 32 29 55 42 sky130_fd_pr__pfet_01v8__model L=0.15U W=1.02U AS=0.2958P AD=0.2958P PS=2.62U PD=2.62U
Mtr_00008 55 19 37 42 sky130_fd_pr__pfet_01v8__model L=0.15U W=1.02U AS=0.2958P AD=0.2958P PS=2.62U PD=2.62U
Mtr_00007 66 8 33 42 sky130_fd_pr__pfet_01v8__model L=0.15U W=2.46U AS=0.7134P AD=0.7134P PS=5.5U PD=5.5U
Mtr_00006 32 7 66 42 sky130_fd_pr__pfet_01v8__model L=0.15U W=2.46U AS=0.7134P AD=0.7134P PS=5.5U PD=5.5U
Mtr_00005 3 48 72 69 sky130_fd_pr__nfet_01v8__model L=0.15U W=0.66U AS=0.1914P AD=0.1914P PS=1.9U PD=1.9U
Mtr_00004 78 23 70 69 sky130_fd_pr__nfet_01v8__model L=0.15U W=1.02U AS=0.2958P AD=0.2958P PS=2.62U PD=2.62U
Mtr_00003 45 17 78 69 sky130_fd_pr__nfet_01v8__model L=0.15U W=1.02U AS=0.2958P AD=0.2958P PS=2.62U PD=2.62U
Mtr_00002 64 1 70 69 sky130_fd_pr__nfet_01v8__model L=0.15U W=1.26U AS=0.3654P AD=0.3654P PS=3.1U PD=3.1U
Mtr_00001 72 2 64 69 sky130_fd_pr__nfet_01v8__model L=0.15U W=1.26U AS=0.3654P AD=0.3654P PS=3.1U PD=3.1U
R8_1 10 9 15
R8_2 13 11 15
R8_3 12 11 15
R8_4 6 5 15
R8_5 4 3 15
R8_6 2 6 288
C8_61 2 69 5.15424e-17
C8_62 6 69 5.15424e-17
R8_7 1 2 192
C8_71 1 69 3.86568e-17
C8_72 2 69 3.86568e-17
R8_8 12 13 26
C8_81 12 69 7.50036e-17
C8_82 13 69 7.50036e-17
R8_9 9 12 52
C8_91 9 69 1.39292e-16
C8_92 12 69 1.39292e-16
R8_10 5 9 26
C8_101 5 69 8.57184e-17
C8_102 9 69 8.57184e-17
R8_11 4 5 39
C8_111 4 69 9.64332e-17
C8_112 5 69 9.64332e-17
R8_12 8 10 288
C8_121 8 69 5.15424e-17
C8_122 10 69 5.15424e-17
R8_13 7 8 192
C8_131 7 69 3.86568e-17
C8_132 8 69 3.86568e-17
R7_1 18 16 15
R7_2 18 19 816
C7_21 18 69 1.3852e-16
C7_22 19 69 1.3852e-16
R7_3 17 18 432
C7_31 17 69 7.40922e-17
C7_32 18 69 7.40922e-17
R6_1 26 25 15
R6_2 28 29 672
C6_21 28 69 1.12749e-16
C6_22 29 69 1.12749e-16
R6_3 27 28 48
C6_31 27 69 1.28856e-17
C6_32 28 69 1.28856e-17
R6_4 26 27 144
C6_41 26 69 2.57712e-17
C6_42 27 69 2.57712e-17
R6_5 22 26 192
C6_51 22 69 3.2214e-17
C6_52 26 69 3.2214e-17
R6_6 22 24 48
C6_61 22 69 1.28856e-17
C6_62 24 69 1.28856e-17
R6_7 23 24 240
C6_71 23 69 4.18782e-17
C6_72 24 69 4.18782e-17
R5_1 36 33 15
R5_2 41 33 15
R5_3 35 33 15
R5_4 33 34 15
R5_5 40 32 15
R5_6 38 32 15
R5_7 39 37 15
R5_8 39 42 26
C5_81 39 69 6.42888e-17
C5_82 42 69 6.42888e-17
R5_9 40 42 26
C5_91 40 69 6.42888e-17
C5_92 42 69 6.42888e-17
R5_10 38 40 13
C5_101 38 69 5.3574e-17
C5_102 40 69 5.3574e-17
R5_11 41 42 26
C5_111 41 69 6.42888e-17
C5_112 42 69 6.42888e-17
R5_12 36 41 26
C5_121 36 69 6.42888e-17
C5_122 41 69 6.42888e-17
R5_13 35 36 26
C5_131 35 69 6.42888e-17
C5_132 36 69 6.42888e-17
R5_14 34 35 13
C5_141 34 69 5.3574e-17
C5_142 35 69 5.3574e-17
R4_1 46 45 15
R4_2 53 52 15
R4_3 57 55 15
R4_4 61 55 15
R4_5 48 49 192
C4_51 48 69 3.86568e-17
C4_52 49 69 3.86568e-17
R4_6 59 60 192
C4_61 59 69 3.86568e-17
C4_62 60 69 3.86568e-17
R4_7 54 60 528
C4_71 54 69 9.01992e-17
C4_72 60 69 9.01992e-17
R4_8 49 54 336
C4_81 49 69 5.79852e-17
C4_82 54 69 5.79852e-17
R4_9 53 54 768
C4_91 53 69 1.35299e-16
C4_92 54 69 1.35299e-16
R4_10 57 61 13
C4_101 57 69 5.3574e-17
C4_102 61 69 5.3574e-17
R4_11 56 57 13
C4_111 56 69 5.3574e-17
C4_112 57 69 5.3574e-17
R4_12 56 58 26
C4_121 56 69 6.42888e-17
C4_122 58 69 6.42888e-17
R4_13 52 58 65
C4_131 52 69 1.50007e-16
C4_132 58 69 1.50007e-16
R4_14 51 52 13
C4_141 51 69 5.3574e-17
C4_142 52 69 5.3574e-17
R4_15 50 51 26
C4_151 50 69 6.42888e-17
C4_152 51 69 6.42888e-17
R4_16 47 50 39
C4_161 47 69 9.64332e-17
C4_162 50 69 9.64332e-17
R4_17 46 47 26
C4_171 46 69 6.42888e-17
C4_172 47 69 6.42888e-17
R3_1 65 64 7.5
R3_2 65 66 3.75
R2_1 71 70 15
R2_2 74 70 15
R2_3 73 72 15
R2_4 75 72 15
R2_5 73 75 26
C2_51 73 69 7.50036e-17
C2_52 75 69 7.50036e-17
R2_6 69 73 26
C2_61 69 69 6.42888e-17
C2_62 73 69 6.42888e-17
R2_7 71 74 13
C2_71 71 69 4.28592e-17
C2_72 74 69 4.28592e-17
R2_8 69 71 26
C2_81 69 69 6.42888e-17
C2_82 71 69 6.42888e-17
.ends na2_x4
