* Spice description of na4_x4
* Spice driver version 131435437
* Date ( dd/mm/yyyy hh:mm:ss ):  8/05/2026 at 14:22:52

* INTERF i0 i1 i2 i3 nq vdd vss

.subckt na4_x4 40 30 24 35 17 57 69
* NET 17 = nq
* NET 24 = i2
* NET 30 = i1
* NET 35 = i3
* NET 40 = i0
* NET 57 = vdd
* NET 69 = vss
Mtr_00014 45 92 11 57 sky130_fd_pr__pfet_01v8__model L=0.15U W=1.26U AS=0.3654P AD=0.3654P PS=3.1U PD=3.1U
Mtr_00013 44 36 96 57 sky130_fd_pr__pfet_01v8__model L=0.15U W=0.9U AS=0.261P AD=0.261P PS=2.38U PD=2.38U
Mtr_00012 94 31 50 57 sky130_fd_pr__pfet_01v8__model L=0.15U W=0.9U AS=0.261P AD=0.261P PS=2.38U PD=2.38U
Mtr_00011 96 26 50 57 sky130_fd_pr__pfet_01v8__model L=0.15U W=0.9U AS=0.261P AD=0.261P PS=2.38U PD=2.38U
Mtr_00010 48 41 94 57 sky130_fd_pr__pfet_01v8__model L=0.15U W=0.9U AS=0.261P AD=0.261P PS=2.38U PD=2.38U
Mtr_00009 44 7 18 57 sky130_fd_pr__pfet_01v8__model L=0.15U W=2.46U AS=0.7134P AD=0.7134P PS=5.5U PD=5.5U
Mtr_00008 18 8 45 57 sky130_fd_pr__pfet_01v8__model L=0.15U W=2.46U AS=0.7134P AD=0.7134P PS=5.5U PD=5.5U
Mtr_00007 3 81 71 69 sky130_fd_pr__nfet_01v8__model L=0.15U W=0.66U AS=0.1914P AD=0.1914P PS=1.9U PD=1.9U
Mtr_00006 63 25 60 69 sky130_fd_pr__nfet_01v8__model L=0.15U W=1.62U AS=0.4698P AD=0.4698P PS=3.82U PD=3.82U
Mtr_00005 63 29 66 69 sky130_fd_pr__nfet_01v8__model L=0.15U W=1.62U AS=0.4698P AD=0.4698P PS=3.82U PD=3.82U
Mtr_00004 66 39 78 69 sky130_fd_pr__nfet_01v8__model L=0.15U W=1.62U AS=0.4698P AD=0.4698P PS=3.82U PD=3.82U
Mtr_00003 71 2 16 69 sky130_fd_pr__nfet_01v8__model L=0.15U W=1.26U AS=0.3654P AD=0.3654P PS=3.1U PD=3.1U
Mtr_00002 16 1 70 69 sky130_fd_pr__nfet_01v8__model L=0.15U W=1.26U AS=0.3654P AD=0.3654P PS=3.1U PD=3.1U
Mtr_00001 60 34 70 69 sky130_fd_pr__nfet_01v8__model L=0.15U W=1.62U AS=0.4698P AD=0.4698P PS=3.82U PD=3.82U
R13_1 4 3 15
R13_2 12 11 15
R13_3 13 11 15
R13_4 10 9 15
R13_5 6 5 15
R13_6 2 6 288
C13_61 2 69 5.15424e-17
C13_62 6 69 5.15424e-17
R13_7 1 2 192
C13_71 1 69 3.86568e-17
C13_72 2 69 3.86568e-17
R13_8 8 10 288
C13_81 8 69 5.15424e-17
C13_82 10 69 5.15424e-17
R13_9 7 8 192
C13_91 7 69 3.86568e-17
C13_92 8 69 3.86568e-17
R13_10 12 13 26
C13_101 12 69 7.50036e-17
C13_102 13 69 7.50036e-17
R13_11 9 12 52
C13_111 9 69 1.39292e-16
C13_112 12 69 1.39292e-16
R13_12 5 9 26
C13_121 5 69 8.57184e-17
C13_122 9 69 8.57184e-17
R13_13 4 5 39
C13_131 4 69 1.07148e-16
C13_132 5 69 1.07148e-16
R12_1 17 16 7.5
R12_2 17 18 3.75
C11 21 69 4.57512e-17
R10_1 25 24 15
R10_2 25 26 1104
C10_21 25 69 1.91673e-16
C10_22 26 69 1.91673e-16
R9_1 29 30 15
R9_2 29 31 1104
C9_21 29 69 1.91673e-16
C9_22 31 69 1.91673e-16
R8_1 34 35 15
R8_2 34 36 1104
C8_21 34 69 1.91673e-16
C8_22 36 69 1.91673e-16
R7_1 39 40 15
R7_2 39 41 1104
C7_21 39 69 1.91673e-16
C7_22 41 69 1.91673e-16
R6_1 44 55 15
R6_2 44 51 15
R6_3 52 45 15
R6_4 47 45 15
R6_5 56 45 15
R6_6 46 45 15
R6_7 54 50 15
R6_8 53 48 15
R6_9 49 48 15
R6_10 53 57 26
C6_101 53 69 6.42888e-17
C6_102 57 69 6.42888e-17
R6_11 49 53 13
C6_111 49 69 4.28592e-17
C6_112 53 69 4.28592e-17
R6_12 54 57 26
C6_121 54 69 6.42888e-17
C6_122 57 69 6.42888e-17
R6_13 56 57 26
C6_131 56 69 6.42888e-17
C6_132 57 69 6.42888e-17
R6_14 52 56 26
C6_141 52 69 6.42888e-17
C6_142 56 69 6.42888e-17
R6_15 47 52 26
C6_151 47 69 6.42888e-17
C6_152 52 69 6.42888e-17
R6_16 46 47 13
C6_161 46 69 5.3574e-17
C6_162 47 69 5.3574e-17
R6_17 55 57 26
C6_171 55 69 6.42888e-17
C6_172 57 69 6.42888e-17
R6_18 51 55 13
C6_181 51 69 5.3574e-17
C6_182 55 69 5.3574e-17
R2_1 70 72 15
R2_2 70 74 15
R2_3 73 71 15
R2_4 75 71 15
R2_5 73 75 26
C2_51 73 69 7.50036e-17
C2_52 75 69 7.50036e-17
R2_6 69 73 26
C2_61 69 69 6.42888e-17
C2_62 73 69 6.42888e-17
R2_7 72 74 13
C2_71 72 69 4.28592e-17
C2_72 74 69 4.28592e-17
R2_8 69 72 26
C2_81 69 69 6.42888e-17
C2_82 72 69 6.42888e-17
R1_1 82 78 15
R1_2 79 78 15
R1_3 83 78 15
R1_4 88 87 15
R1_5 97 96 15
R1_6 95 94 15
R1_7 99 96 15
R1_8 98 94 15
R1_9 81 86 192
C1_91 81 69 3.86568e-17
C1_92 86 69 3.86568e-17
R1_10 92 93 192
C1_101 92 69 3.86568e-17
C1_102 93 69 3.86568e-17
R1_11 95 98 13
C1_111 95 69 4.82166e-17
C1_112 98 69 4.82166e-17
R1_12 89 93 528
C1_121 89 69 9.01992e-17
C1_122 93 69 9.01992e-17
R1_13 86 89 336
C1_131 86 69 5.79852e-17
C1_132 89 69 5.79852e-17
R1_14 97 99 13
C1_141 97 69 4.82166e-17
C1_142 99 69 4.82166e-17
R1_15 95 97 52
C1_151 95 69 1.33935e-16
C1_152 97 69 1.33935e-16
R1_16 88 89 768
C1_161 88 69 1.28856e-16
C1_162 89 69 1.28856e-16
R1_17 90 97 26
C1_171 90 69 5.89314e-17
C1_172 97 69 5.89314e-17
R1_18 90 91 26
C1_181 90 69 6.42888e-17
C1_182 91 69 6.42888e-17
R1_19 87 91 65
C1_191 87 69 1.50007e-16
C1_192 91 69 1.50007e-16
R1_20 85 87 13
C1_201 85 69 5.3574e-17
C1_202 87 69 5.3574e-17
R1_21 84 85 26
C1_211 84 69 7.50036e-17
C1_212 85 69 7.50036e-17
R1_22 80 84 39
C1_221 80 69 9.64332e-17
C1_222 84 69 9.64332e-17
R1_23 79 80 78
C1_231 79 69 1.92866e-16
C1_232 80 69 1.92866e-16
R1_24 82 83 13
C1_241 82 69 4.28592e-17
C1_242 83 69 4.28592e-17
R1_25 79 82 13
C1_251 79 69 5.3574e-17
C1_252 82 69 5.3574e-17
.ends na4_x4
