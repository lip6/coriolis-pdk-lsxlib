* Spice description of no3_x1
* Spice driver version 1020820397
* Date ( dd/mm/yyyy hh:mm:ss ):  8/05/2026 at 14:22:52

* INTERF i0 i1 i2 nq vdd vss

.subckt no3_x1 11 1 7 32 25 38
* NET 1 = i1
* NET 7 = i2
* NET 11 = i0
* NET 25 = vdd
* NET 32 = nq
* NET 38 = vss
Mtr_00006 19 13 33 25 sky130_fd_pr__pfet_01v8__model L=0.15U W=2.46U AS=0.7134P AD=0.7134P PS=5.5U PD=5.5U
Mtr_00005 16 3 19 25 sky130_fd_pr__pfet_01v8__model L=0.15U W=2.46U AS=0.7134P AD=0.7134P PS=5.5U PD=5.5U
Mtr_00004 22 8 16 25 sky130_fd_pr__pfet_01v8__model L=0.15U W=2.46U AS=0.7134P AD=0.7134P PS=5.5U PD=5.5U
Mtr_00003 39 2 31 38 sky130_fd_pr__nfet_01v8__model L=0.15U W=0.66U AS=0.1914P AD=0.1914P PS=1.9U PD=1.9U
Mtr_00002 31 6 41 38 sky130_fd_pr__nfet_01v8__model L=0.15U W=0.66U AS=0.1914P AD=0.1914P PS=1.9U PD=1.9U
Mtr_00001 28 12 39 38 sky130_fd_pr__nfet_01v8__model L=0.15U W=0.66U AS=0.1914P AD=0.1914P PS=1.9U PD=1.9U
R8_1 3 1 15
R8_2 2 3 1008
C8_21 2 38 1.75566e-16
C8_22 3 38 1.75566e-16
R7_1 8 7 15
R7_2 6 8 1008
C7_21 6 38 1.75566e-16
C7_22 8 38 1.75566e-16
R6_1 13 11 15
R6_2 12 13 1008
C6_21 12 38 1.75566e-16
C6_22 13 38 1.75566e-16
R3_1 24 22 15
R3_2 23 22 15
R3_3 24 25 26
C3_31 24 38 6.42888e-17
C3_32 25 38 6.42888e-17
R3_4 23 24 13
C3_41 23 38 5.3574e-17
C3_42 24 38 5.3574e-17
R2_1 32 31 15
R2_2 34 33 15
R2_3 35 33 15
R2_4 30 28 15
R2_5 30 29 13
C2_51 30 38 5.3574e-17
C2_52 29 38 5.3574e-17
R2_6 35 34 13
C2_61 35 38 5.3574e-17
C2_62 34 38 5.3574e-17
R2_7 29 32 52
C2_71 29 38 1.28578e-16
C2_72 32 38 1.28578e-16
R2_8 34 32 52
C2_81 34 38 1.28578e-16
C2_82 32 38 1.28578e-16
R1_1 40 39 15
R1_2 42 41 15
R1_3 38 42 26
C1_31 38 38 6.42888e-17
C1_32 42 38 6.42888e-17
R1_4 38 40 26
C1_41 38 38 6.42888e-17
C1_42 40 38 6.42888e-17
.ends no3_x1
