* Spice description of buf_x4
* Spice driver version -1147855955
* Date ( dd/mm/yyyy hh:mm:ss ):  8/05/2026 at 14:22:51

* INTERF i q vdd vss

.subckt buf_x4 1 34 14 38
* NET 1 = i
* NET 14 = vdd
* NET 34 = q
* NET 38 = vss
Mtr_00006 8 26 35 14 sky130_fd_pr__pfet_01v8__model L=0.15U W=2.46U AS=0.7134P AD=0.7134P PS=5.5U PD=5.5U
Mtr_00005 7 4 27 14 sky130_fd_pr__pfet_01v8__model L=0.15U W=1.26U AS=0.3654P AD=0.3654P PS=3.1U PD=3.1U
Mtr_00004 35 25 7 14 sky130_fd_pr__pfet_01v8__model L=0.15U W=2.46U AS=0.7134P AD=0.7134P PS=5.5U PD=5.5U
Mtr_00003 33 22 40 38 sky130_fd_pr__nfet_01v8__model L=0.15U W=1.26U AS=0.3654P AD=0.3654P PS=3.1U PD=3.1U
Mtr_00002 17 2 39 38 sky130_fd_pr__nfet_01v8__model L=0.15U W=0.66U AS=0.1914P AD=0.1914P PS=1.9U PD=1.9U
Mtr_00001 39 20 33 38 sky130_fd_pr__nfet_01v8__model L=0.15U W=1.26U AS=0.3654P AD=0.3654P PS=3.1U PD=3.1U
R5_1 3 1 15
R5_2 3 4 672
C5_21 3 38 1.19192e-16
C5_22 4 38 1.19192e-16
R5_3 2 3 576
C5_31 2 38 9.6642e-17
C5_32 3 38 9.6642e-17
R4_1 13 8 15
R4_2 11 8 15
R4_3 10 8 15
R4_4 8 9 15
R4_5 12 7 15
R4_6 12 14 26
C4_61 12 38 6.42888e-17
C4_62 14 38 6.42888e-17
R4_7 13 14 26
C4_71 13 38 6.42888e-17
C4_72 14 38 6.42888e-17
R4_8 11 13 26
C4_81 11 38 6.42888e-17
C4_82 13 38 6.42888e-17
R4_9 10 11 13
C4_91 10 38 5.3574e-17
C4_92 11 38 5.3574e-17
R4_10 9 10 26
C4_101 9 38 6.42888e-17
C4_102 10 38 6.42888e-17
R3_1 18 17 15
R3_2 24 23 15
R3_3 28 27 15
R3_4 30 27 15
R3_5 24 26 480
C3_51 24 38 8.69778e-17
C3_52 26 38 8.69778e-17
R3_6 22 24 480
C3_61 22 38 8.0535e-17
C3_62 24 38 8.0535e-17
R3_7 24 25 480
C3_71 24 38 8.69778e-17
C3_72 25 38 8.69778e-17
R3_8 20 24 480
C3_81 20 38 8.0535e-17
C3_82 24 38 8.0535e-17
R3_9 28 30 13
C3_91 28 38 5.3574e-17
C3_92 30 38 5.3574e-17
R3_10 28 29 26
C3_101 28 38 7.50036e-17
C3_102 29 38 7.50036e-17
R3_11 23 29 78
C3_111 23 38 1.82152e-16
C3_112 29 38 1.82152e-16
R3_12 21 23 52
C3_121 21 38 1.17863e-16
C3_122 23 38 1.17863e-16
R3_13 19 21 26
C3_131 19 38 7.50036e-17
C3_132 21 38 7.50036e-17
R3_14 18 19 13
C3_141 18 38 5.3574e-17
C3_142 19 38 5.3574e-17
R2_1 34 33 7.5
R2_2 34 35 3.75
R1_1 41 39 15
R1_2 43 40 15
R1_3 42 40 15
R1_4 42 43 26
C1_41 42 38 7.50036e-17
C1_42 43 38 7.50036e-17
R1_5 38 42 26
C1_51 38 38 6.42888e-17
C1_52 42 38 6.42888e-17
R1_6 38 41 26
C1_61 38 38 6.42888e-17
C1_62 41 38 6.42888e-17
.ends buf_x4
