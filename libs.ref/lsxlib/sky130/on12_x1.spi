* Spice description of on12_x1
* Spice driver version -1514927187
* Date ( dd/mm/yyyy hh:mm:ss ):  8/05/2026 at 14:22:51

* INTERF i0 i1 q vdd vss

.subckt on12_x1 8 14 37 5 41
* NET 5 = vdd
* NET 8 = i0
* NET 14 = i1
* NET 37 = q
* NET 41 = vss
Mtr_00006 2 18 27 5 sky130_fd_pr__pfet_01v8__model L=0.15U W=1.02U AS=0.2958P AD=0.2958P PS=2.62U PD=2.62U
Mtr_00005 38 26 2 5 sky130_fd_pr__pfet_01v8__model L=0.15U W=1.26U AS=0.3654P AD=0.3654P PS=3.1U PD=3.1U
Mtr_00004 1 11 38 5 sky130_fd_pr__pfet_01v8__model L=0.15U W=1.26U AS=0.3654P AD=0.3654P PS=3.1U PD=3.1U
Mtr_00003 22 16 42 41 sky130_fd_pr__nfet_01v8__model L=0.15U W=0.54U AS=0.1566P AD=0.1566P PS=1.66U PD=1.66U
Mtr_00002 42 21 32 41 sky130_fd_pr__nfet_01v8__model L=0.15U W=1.26U AS=0.3654P AD=0.3654P PS=3.1U PD=3.1U
Mtr_00001 32 9 35 41 sky130_fd_pr__nfet_01v8__model L=0.15U W=1.26U AS=0.3654P AD=0.3654P PS=3.1U PD=3.1U
R7_1 4 2 15
R7_2 3 1 15
R7_3 3 5 26
C7_31 3 41 6.42888e-17
C7_32 5 41 6.42888e-17
R7_4 4 5 26
C7_41 4 41 6.42888e-17
C7_42 5 41 6.42888e-17
R6_1 10 8 15
R6_2 10 11 672
C6_21 10 41 1.19192e-16
C6_22 11 41 1.19192e-16
R6_3 9 10 480
C6_31 9 41 8.0535e-17
C6_32 10 41 8.0535e-17
R5_1 17 14 15
R5_2 15 14 15
R5_3 16 15 384
C5_31 16 41 6.76494e-17
C5_32 15 41 6.76494e-17
R5_4 17 18 480
C5_41 17 41 8.69778e-17
C5_42 18 41 8.69778e-17
R4_1 23 22 15
R4_2 28 27 15
R4_3 29 27 15
R4_4 24 25 15
R4_5 24 26 672
C4_51 24 41 1.19192e-16
C4_52 26 41 1.19192e-16
R4_6 21 24 480
C4_61 21 41 8.0535e-17
C4_62 24 41 8.0535e-17
R4_7 29 28 13
C4_71 29 41 5.3574e-17
C4_72 28 41 5.3574e-17
R4_8 25 29 78
C4_81 25 41 1.82152e-16
C4_82 29 41 1.82152e-16
R4_9 23 25 65
C4_91 23 41 1.71437e-16
C4_92 25 41 1.71437e-16
R2_1 36 35 15
R2_2 37 38 7.5
R2_3 36 37 26
C2_31 36 41 6.42888e-17
C2_32 37 41 6.42888e-17
R1_1 43 42 15
R1_2 41 43 26
C1_21 41 41 6.42888e-17
C1_22 43 41 6.42888e-17
.ends on12_x1
