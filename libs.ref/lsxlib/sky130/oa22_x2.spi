* Spice description of oa22_x2
* Spice driver version -105616467
* Date ( dd/mm/yyyy hh:mm:ss ):  8/05/2026 at 14:23:17

* INTERF i0 i1 i2 q vdd vss

.subckt oa22_x2 8 14 20 48 29 52
* NET 8 = i0
* NET 14 = i1
* NET 20 = i2
* NET 29 = vdd
* NET 48 = q
* NET 52 = vss
Mtr_00008 27 42 49 29 sky130_fd_pr__pfet_01v8__model L=0.15U W=2.22U AS=0.6438P AD=0.6438P PS=5.02U PD=5.02U
Mtr_00007 3 17 41 29 sky130_fd_pr__pfet_01v8__model L=0.15U W=1.26U AS=0.3654P AD=0.3654P PS=3.1U PD=3.1U
Mtr_00006 27 24 3 29 sky130_fd_pr__pfet_01v8__model L=0.15U W=1.26U AS=0.3654P AD=0.3654P PS=3.1U PD=3.1U
Mtr_00005 41 11 1 29 sky130_fd_pr__pfet_01v8__model L=0.15U W=1.26U AS=0.3654P AD=0.3654P PS=3.1U PD=3.1U
Mtr_00004 47 37 54 52 sky130_fd_pr__nfet_01v8__model L=0.15U W=1.26U AS=0.3654P AD=0.3654P PS=3.1U PD=3.1U
Mtr_00003 53 9 32 52 sky130_fd_pr__nfet_01v8__model L=0.15U W=0.66U AS=0.1914P AD=0.1914P PS=1.9U PD=1.9U
Mtr_00002 32 15 35 52 sky130_fd_pr__nfet_01v8__model L=0.15U W=0.66U AS=0.1914P AD=0.1914P PS=1.9U PD=1.9U
Mtr_00001 35 21 54 52 sky130_fd_pr__nfet_01v8__model L=0.15U W=0.66U AS=0.1914P AD=0.1914P PS=1.9U PD=1.9U
R9_1 5 3 15
R9_2 4 1 15
R9_3 2 1 15
R9_4 2 4 13
C9_41 2 52 5.3574e-17
C9_42 4 52 5.3574e-17
R9_5 4 5 52
C9_51 4 52 1.28578e-16
C9_52 5 52 1.28578e-16
R8_1 10 8 15
R8_2 10 11 768
C8_21 10 52 1.32077e-16
C8_22 11 52 1.32077e-16
R8_3 9 10 480
C8_31 9 52 8.37564e-17
C8_32 10 52 8.37564e-17
R7_1 16 14 15
R7_2 16 17 768
C7_21 16 52 1.29661e-16
C7_22 17 52 1.29661e-16
R7_3 15 16 480
C7_31 15 52 8.13404e-17
C7_32 16 52 8.13404e-17
R6_1 22 20 15
R6_2 23 20 15
R6_3 23 24 576
C6_31 23 52 9.90581e-17
C6_32 24 52 9.90581e-17
R6_4 21 22 336
C6_41 21 52 6.36227e-17
C6_42 22 52 6.36227e-17
R5_1 28 27 15
R5_2 28 29 26
C5_21 28 52 6.42888e-17
C5_22 29 52 6.42888e-17
R3_1 36 35 15
R3_2 39 38 15
R3_3 43 41 15
R3_4 40 42 576
C3_41 40 52 9.98634e-17
C3_42 42 52 9.98634e-17
R3_5 37 40 432
C3_51 37 52 7.40922e-17
C3_52 40 52 7.40922e-17
R3_6 39 40 336
C3_61 39 52 5.79852e-17
C3_62 40 52 5.79852e-17
R3_7 43 44 26
C3_71 43 52 6.42888e-17
C3_72 44 52 6.42888e-17
R3_8 38 44 78
C3_81 38 52 1.92866e-16
C3_82 44 52 1.92866e-16
R3_9 36 38 65
C3_91 36 52 1.60722e-16
C3_92 38 52 1.60722e-16
R2_1 47 48 7.5
R2_2 48 49 3.75
R1_1 56 54 15
R1_2 55 53 15
R1_3 52 55 26
C1_31 52 52 6.42888e-17
C1_32 55 52 6.42888e-17
R1_4 52 56 26
C1_41 52 52 6.42888e-17
C1_42 56 52 6.42888e-17
.ends oa22_x2
