* Spice description of oa2a2a2a24_x4
* Spice driver version -1377309779
* Date ( dd/mm/yyyy hh:mm:ss ):  8/05/2026 at 14:22:51

* INTERF i0 i1 i2 i3 i4 i5 i6 i7 q vdd vss

.subckt oa2a2a2a24_x4 45 57 53 64 12 6 18 24 2 81 121
* NET 2 = q
* NET 6 = i5
* NET 12 = i4
* NET 18 = i6
* NET 24 = i7
* NET 45 = i0
* NET 53 = i2
* NET 57 = i1
* NET 64 = i3
* NET 81 = vdd
* NET 121 = vss
Mtr_00020 91 60 69 81 sky130_fd_pr__pfet_01v8__model L=0.15U W=2.46U AS=0.7134P AD=0.7134P PS=5.5U PD=5.5U
Mtr_00019 92 52 84 81 sky130_fd_pr__pfet_01v8__model L=0.15U W=2.46U AS=0.7134P AD=0.7134P PS=5.5U PD=5.5U
Mtr_00018 32 27 116 81 sky130_fd_pr__pfet_01v8__model L=0.15U W=2.46U AS=0.7134P AD=0.7134P PS=5.5U PD=5.5U
Mtr_00017 69 48 90 81 sky130_fd_pr__pfet_01v8__model L=0.15U W=2.46U AS=0.7134P AD=0.7134P PS=5.5U PD=5.5U
Mtr_00016 116 21 31 81 sky130_fd_pr__pfet_01v8__model L=0.15U W=2.46U AS=0.7134P AD=0.7134P PS=5.5U PD=5.5U
Mtr_00015 85 15 30 81 sky130_fd_pr__pfet_01v8__model L=0.15U W=2.46U AS=0.7134P AD=0.7134P PS=5.5U PD=5.5U
Mtr_00014 84 65 91 81 sky130_fd_pr__pfet_01v8__model L=0.15U W=2.46U AS=0.7134P AD=0.7134P PS=5.5U PD=5.5U
Mtr_00013 31 9 85 81 sky130_fd_pr__pfet_01v8__model L=0.15U W=2.46U AS=0.7134P AD=0.7134P PS=5.5U PD=5.5U
Mtr_00012 72 114 3 81 sky130_fd_pr__pfet_01v8__model L=0.15U W=2.46U AS=0.7134P AD=0.7134P PS=5.5U PD=5.5U
Mtr_00011 3 115 70 81 sky130_fd_pr__pfet_01v8__model L=0.15U W=2.46U AS=0.7134P AD=0.7134P PS=5.5U PD=5.5U
Mtr_00010 106 19 42 121 sky130_fd_pr__nfet_01v8__model L=0.15U W=0.9U AS=0.261P AD=0.261P PS=2.38U PD=2.38U
Mtr_00009 42 25 128 121 sky130_fd_pr__nfet_01v8__model L=0.15U W=0.9U AS=0.261P AD=0.261P PS=2.38U PD=2.38U
Mtr_00008 122 46 100 121 sky130_fd_pr__nfet_01v8__model L=0.15U W=0.9U AS=0.261P AD=0.261P PS=2.38U PD=2.38U
Mtr_00007 100 58 103 121 sky130_fd_pr__nfet_01v8__model L=0.15U W=0.9U AS=0.261P AD=0.261P PS=2.38U PD=2.38U
Mtr_00006 103 63 138 121 sky130_fd_pr__nfet_01v8__model L=0.15U W=0.9U AS=0.261P AD=0.261P PS=2.38U PD=2.38U
Mtr_00005 138 51 124 121 sky130_fd_pr__nfet_01v8__model L=0.15U W=0.9U AS=0.261P AD=0.261P PS=2.38U PD=2.38U
Mtr_00004 126 13 39 121 sky130_fd_pr__nfet_01v8__model L=0.15U W=0.9U AS=0.261P AD=0.261P PS=2.38U PD=2.38U
Mtr_00003 39 7 106 121 sky130_fd_pr__nfet_01v8__model L=0.15U W=0.9U AS=0.261P AD=0.261P PS=2.38U PD=2.38U
Mtr_00002 130 111 1 121 sky130_fd_pr__nfet_01v8__model L=0.15U W=1.26U AS=0.3654P AD=0.3654P PS=3.1U PD=3.1U
Mtr_00001 1 110 132 121 sky130_fd_pr__nfet_01v8__model L=0.15U W=1.26U AS=0.3654P AD=0.3654P PS=3.1U PD=3.1U
R19_1 2 1 7.5
R19_2 2 3 3.75
R18_1 8 6 15
R18_2 8 9 528
C18_21 8 121 9.34206e-17
C18_22 9 121 9.34206e-17
R18_3 7 8 480
C18_31 7 121 8.37564e-17
C18_32 8 121 8.37564e-17
R17_1 14 12 15
R17_2 14 15 528
C17_21 14 121 9.34206e-17
C17_22 15 121 9.34206e-17
R17_3 13 14 480
C17_31 13 121 8.37564e-17
C17_32 14 121 8.37564e-17
R16_1 20 18 15
R16_2 20 21 528
C16_21 20 121 9.34206e-17
C16_22 21 121 9.34206e-17
R16_3 19 20 480
C16_31 19 121 8.37564e-17
C16_32 20 121 8.37564e-17
R15_1 26 24 15
R15_2 26 27 528
C15_21 26 121 9.34206e-17
C15_22 27 121 9.34206e-17
R15_3 25 26 480
C15_31 25 121 8.37564e-17
C15_32 26 121 8.37564e-17
R14_1 32 36 15
R14_2 35 31 15
R14_3 34 31 15
R14_4 33 30 15
R14_5 33 34 52
C14_51 33 121 1.28578e-16
C14_52 34 121 1.28578e-16
R14_6 34 35 13
C14_61 34 121 5.3574e-17
C14_62 35 121 5.3574e-17
R14_7 35 36 52
C14_71 35 121 1.28578e-16
C14_72 36 121 1.28578e-16
R11_1 47 45 15
R11_2 47 48 528
C11_21 47 121 9.34206e-17
C11_22 48 121 9.34206e-17
R11_3 46 47 480
C11_31 46 121 8.37564e-17
C11_32 47 121 8.37564e-17
R10_1 54 53 15
R10_2 54 52 528
C10_21 54 121 9.34206e-17
C10_22 52 121 9.34206e-17
R10_3 51 54 480
C10_31 51 121 8.37564e-17
C10_32 54 121 8.37564e-17
R9_1 59 57 15
R9_2 59 60 528
C9_21 59 121 9.34206e-17
C9_22 60 121 9.34206e-17
R9_3 58 59 480
C9_31 58 121 8.37564e-17
C9_32 59 121 8.37564e-17
R8_1 66 64 15
R8_2 66 65 528
C8_21 66 121 9.34206e-17
C8_22 65 121 9.34206e-17
R8_3 63 66 480
C8_31 63 121 8.37564e-17
C8_32 66 121 8.37564e-17
R7_1 78 69 15
R7_2 79 70 15
R7_3 74 70 15
R7_4 76 70 15
R7_5 71 70 15
R7_6 77 72 15
R7_7 75 72 15
R7_8 80 72 15
R7_9 73 72 15
R7_10 80 81 26
C7_101 80 121 6.42888e-17
C7_102 81 121 6.42888e-17
R7_11 77 80 13
C7_111 77 121 5.3574e-17
C7_112 80 121 5.3574e-17
R7_12 75 77 26
C7_121 75 121 6.42888e-17
C7_122 77 121 6.42888e-17
R7_13 73 75 26
C7_131 73 121 6.42888e-17
C7_132 75 121 6.42888e-17
R7_14 79 81 26
C7_141 79 121 6.42888e-17
C7_142 81 121 6.42888e-17
R7_15 76 79 13
C7_151 76 121 5.3574e-17
C7_152 79 121 5.3574e-17
R7_16 74 76 26
C7_161 74 121 6.42888e-17
C7_162 76 121 6.42888e-17
R7_17 71 74 26
C7_171 71 121 6.42888e-17
C7_172 74 121 6.42888e-17
R7_18 78 81 26
C7_181 78 121 6.42888e-17
C7_182 81 121 6.42888e-17
R6_1 86 84 15
R6_2 87 85 15
R6_3 86 87 78
C6_31 86 121 1.92866e-16
C6_32 87 121 1.92866e-16
R5_1 95 92 15
R5_2 94 91 15
R5_3 93 90 15
R5_4 96 90 15
R5_5 97 91 15
R5_6 94 97 13
C5_61 94 121 5.3574e-17
C5_62 97 121 5.3574e-17
R5_7 93 96 13
C5_71 93 121 5.3574e-17
C5_72 96 121 5.3574e-17
R5_8 94 95 52
C5_81 94 121 1.28578e-16
C5_82 95 121 1.28578e-16
R5_9 93 94 52
C5_91 93 121 1.28578e-16
C5_92 94 121 1.28578e-16
R3_1 104 103 15
R3_2 113 112 15
R3_3 107 106 15
R3_4 117 116 15
R3_5 113 115 528
C3_51 113 121 9.34206e-17
C3_52 115 121 9.34206e-17
R3_6 111 113 432
C3_61 111 121 7.40922e-17
C3_62 113 121 7.40922e-17
R3_7 113 114 528
C3_71 113 121 9.34206e-17
C3_72 114 121 9.34206e-17
R3_8 110 113 432
C3_81 110 121 7.40922e-17
C3_82 113 121 7.40922e-17
R3_9 117 118 26
C3_91 117 121 7.50036e-17
C3_92 118 121 7.50036e-17
R3_10 107 108 13
C3_101 107 121 5.3574e-17
C3_102 108 121 5.3574e-17
R3_11 112 118 78
C3_111 112 121 1.92866e-16
C3_112 118 121 1.92866e-16
R3_12 109 112 39
C3_121 109 121 1.07148e-16
C3_122 112 121 1.07148e-16
R3_13 108 109 52
C3_131 108 121 1.39292e-16
C3_132 109 121 1.39292e-16
R3_14 105 108 130
C3_141 105 121 3.21444e-16
C3_142 108 121 3.21444e-16
R3_15 104 105 13
C3_151 104 121 5.3574e-17
C3_152 105 121 5.3574e-17
R2_1 125 124 15
R2_2 131 130 15
R2_3 134 130 15
R2_4 133 132 15
R2_5 135 132 15
R2_6 127 126 15
R2_7 129 128 15
R2_8 123 122 15
R2_9 121 123 26
C2_91 121 121 6.42888e-17
C2_92 123 121 6.42888e-17
R2_10 121 129 26
C2_101 121 121 6.42888e-17
C2_102 129 121 6.42888e-17
R2_11 121 127 26
C2_111 121 121 6.42888e-17
C2_112 127 121 6.42888e-17
R2_12 133 135 26
C2_121 133 121 7.50036e-17
C2_122 135 121 7.50036e-17
R2_13 121 133 26
C2_131 121 121 6.42888e-17
C2_132 133 121 6.42888e-17
R2_14 131 134 26
C2_141 131 121 7.50036e-17
C2_142 134 121 7.50036e-17
R2_15 121 131 26
C2_151 121 121 6.42888e-17
C2_152 131 121 6.42888e-17
R2_16 121 125 26
C2_161 121 121 6.42888e-17
C2_162 125 121 6.42888e-17
.ends oa2a2a2a24_x4
