* Spice description of ao22_x4
* Spice driver version -1455678547
* Date ( dd/mm/yyyy hh:mm:ss ):  8/05/2026 at 14:22:51

* INTERF i0 i1 i2 q vdd vss

.subckt ao22_x4 9 20 27 5 45 68
* NET 5 = q
* NET 9 = i0
* NET 20 = i1
* NET 27 = i2
* NET 45 = vdd
* NET 68 = vss
Mtr_00011 6 56 35 45 sky130_fd_pr__pfet_01v8__model L=0.15U W=2.46U AS=0.7134P AD=0.7134P PS=5.5U PD=5.5U
Mtr_00010 6 56 35 45 sky130_fd_pr__pfet_01v8__model L=0.15U W=2.46U AS=0.7134P AD=0.7134P PS=5.5U PD=5.5U
Mtr_00009 33 55 6 45 sky130_fd_pr__pfet_01v8__model L=0.15U W=2.46U AS=0.7134P AD=0.7134P PS=5.5U PD=5.5U
Mtr_00008 1 24 57 45 sky130_fd_pr__pfet_01v8__model L=0.15U W=1.26U AS=0.3654P AD=0.3654P PS=3.1U PD=3.1U
Mtr_00007 39 14 1 45 sky130_fd_pr__pfet_01v8__model L=0.15U W=1.26U AS=0.3654P AD=0.3654P PS=3.1U PD=3.1U
Mtr_00006 57 30 33 45 sky130_fd_pr__pfet_01v8__model L=0.15U W=1.26U AS=0.3654P AD=0.3654P PS=3.1U PD=3.1U
Mtr_00005 4 50 69 68 sky130_fd_pr__nfet_01v8__model L=0.15U W=1.26U AS=0.3654P AD=0.3654P PS=3.1U PD=3.1U
Mtr_00004 71 51 4 68 sky130_fd_pr__nfet_01v8__model L=0.15U W=1.26U AS=0.3654P AD=0.3654P PS=3.1U PD=3.1U
Mtr_00003 69 28 64 68 sky130_fd_pr__nfet_01v8__model L=0.15U W=0.66U AS=0.1914P AD=0.1914P PS=1.9U PD=1.9U
Mtr_00002 64 18 48 68 sky130_fd_pr__nfet_01v8__model L=0.15U W=0.66U AS=0.1914P AD=0.1914P PS=1.9U PD=1.9U
Mtr_00001 48 11 62 68 sky130_fd_pr__nfet_01v8__model L=0.15U W=0.66U AS=0.1914P AD=0.1914P PS=1.9U PD=1.9U
R8_1 5 4 7.5
R8_2 5 6 3.75
R7_1 12 9 15
R7_2 10 11 48
C7_21 10 68 1.28856e-17
C7_22 11 68 1.28856e-17
R7_3 13 14 48
C7_31 13 68 1.28856e-17
C7_32 14 68 1.28856e-17
R7_4 12 13 384
C7_41 12 68 7.08708e-17
C7_42 13 68 7.08708e-17
R7_5 10 12 432
C7_51 10 68 7.73136e-17
C7_52 12 68 7.73136e-17
R6_1 21 20 15
R6_2 23 24 432
C6_21 23 68 7.40922e-17
C6_22 24 68 7.40922e-17
R6_3 22 23 48
C6_31 22 68 1.28856e-17
C6_32 23 68 1.28856e-17
R6_4 21 22 192
C6_41 21 68 3.86568e-17
C6_42 22 68 3.86568e-17
R6_5 17 21 336
C6_51 17 68 5.79852e-17
C6_52 21 68 5.79852e-17
R6_6 18 19 240
C6_61 18 68 4.50996e-17
C6_62 19 68 4.50996e-17
R6_7 17 19 48
C6_71 17 68 1.28856e-17
C6_72 19 68 1.28856e-17
R5_1 29 27 15
R5_2 28 27 15
R5_3 29 30 672
C5_31 29 68 1.12749e-16
C5_32 30 68 1.12749e-16
R4_1 33 34 7.5
R4_2 43 33 7.5
R4_3 40 33 7.5
R4_4 37 33 7.5
R4_5 44 35 7.5
R4_6 41 35 7.5
R4_7 38 35 7.5
R4_8 36 35 7.5
R4_9 42 39 15
R4_10 42 45 26
C4_101 42 68 6.42888e-17
C4_102 45 68 6.42888e-17
R4_11 44 45 26
C4_111 44 68 6.42888e-17
C4_112 45 68 6.42888e-17
R4_12 41 44 26
C4_121 41 68 6.42888e-17
C4_122 44 68 6.42888e-17
R4_13 38 41 26
C4_131 38 68 6.42888e-17
C4_132 41 68 6.42888e-17
R4_14 36 38 13
C4_141 36 68 5.3574e-17
C4_142 38 68 5.3574e-17
R4_15 43 45 26
C4_151 43 68 6.42888e-17
C4_152 45 68 6.42888e-17
R4_16 40 43 26
C4_161 40 68 6.42888e-17
C4_162 43 68 6.42888e-17
R4_17 37 40 26
C4_171 37 68 6.42888e-17
C4_172 40 68 6.42888e-17
R4_18 34 37 13
C4_181 34 68 5.3574e-17
C4_182 37 68 5.3574e-17
R3_1 48 49 15
R3_2 54 53 15
R3_3 59 57 15
R3_4 58 57 15
R3_5 54 55 672
C3_51 54 68 1.12749e-16
C3_52 55 68 1.12749e-16
R3_6 50 54 288
C3_61 50 68 5.47638e-17
C3_62 54 68 5.47638e-17
R3_7 54 56 672
C3_71 54 68 1.12749e-16
C3_72 56 68 1.12749e-16
R3_8 51 54 288
C3_81 51 68 5.47638e-17
C3_82 54 68 5.47638e-17
R3_9 58 59 13
C3_91 58 68 5.3574e-17
C3_92 59 68 5.3574e-17
R3_10 53 58 91
C3_101 53 68 2.19653e-16
C3_102 58 68 2.19653e-16
R3_11 52 53 13
C3_111 52 68 5.3574e-17
C3_112 53 68 5.3574e-17
R3_12 49 52 26
C3_121 49 68 6.42888e-17
C3_122 52 68 6.42888e-17
R2_1 63 62 15
R2_2 65 64 15
R2_3 63 65 52
C2_31 63 68 1.28578e-16
C2_32 65 68 1.28578e-16
R1_1 69 70 15
R1_2 73 69 15
R1_3 72 71 15
R1_4 74 71 15
R1_5 72 74 26
C1_51 72 68 7.50036e-17
C1_52 74 68 7.50036e-17
R1_6 68 72 26
C1_61 68 68 6.42888e-17
C1_62 72 68 6.42888e-17
R1_7 70 73 26
C1_71 70 68 7.50036e-17
C1_72 73 68 7.50036e-17
R1_8 68 70 26
C1_81 68 68 6.42888e-17
C1_82 70 68 6.42888e-17
.ends ao22_x4
