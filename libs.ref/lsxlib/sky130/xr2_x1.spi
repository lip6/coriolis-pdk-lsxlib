* Spice description of xr2_x1
* Spice driver version -50173011
* Date ( dd/mm/yyyy hh:mm:ss ):  8/05/2026 at 14:22:51

* INTERF i0 i1 q q vdd vss

.subckt xr2_x1 4 11 56 61 39 67
* NET 4 = i0
* NET 11 = i1
* NET 39 = vdd
* NET 56 = q
* NET 61 = q
* NET 67 = vss
Mtr_00012 35 7 80 39 sky130_fd_pr__pfet_01v8__model L=0.15U W=1.26U AS=0.3654P AD=0.3654P PS=3.1U PD=3.1U
Mtr_00011 30 17 36 39 sky130_fd_pr__pfet_01v8__model L=0.15U W=1.26U AS=0.3654P AD=0.3654P PS=3.1U PD=3.1U
Mtr_00010 36 15 43 39 sky130_fd_pr__pfet_01v8__model L=0.15U W=2.34U AS=0.6786P AD=0.6786P PS=5.26U PD=5.26U
Mtr_00009 43 82 60 39 sky130_fd_pr__pfet_01v8__model L=0.15U W=2.34U AS=0.6786P AD=0.6786P PS=5.26U PD=5.26U
Mtr_00008 42 6 35 39 sky130_fd_pr__pfet_01v8__model L=0.15U W=2.34U AS=0.6786P AD=0.6786P PS=5.26U PD=5.26U
Mtr_00007 60 28 42 39 sky130_fd_pr__pfet_01v8__model L=0.15U W=2.34U AS=0.6786P AD=0.6786P PS=5.26U PD=5.26U
Mtr_00006 70 12 21 67 sky130_fd_pr__nfet_01v8__model L=0.15U W=0.66U AS=0.1914P AD=0.1914P PS=1.9U PD=1.9U
Mtr_00005 74 1 68 67 sky130_fd_pr__nfet_01v8__model L=0.15U W=0.66U AS=0.1914P AD=0.1914P PS=1.9U PD=1.9U
Mtr_00004 53 20 70 67 sky130_fd_pr__nfet_01v8__model L=0.15U W=1.14U AS=0.3306P AD=0.3306P PS=2.86U PD=2.86U
Mtr_00003 57 76 53 67 sky130_fd_pr__nfet_01v8__model L=0.15U W=1.14U AS=0.3306P AD=0.3306P PS=2.86U PD=2.86U
Mtr_00002 64 10 57 67 sky130_fd_pr__nfet_01v8__model L=0.15U W=1.14U AS=0.3306P AD=0.3306P PS=2.86U PD=2.86U
Mtr_00001 68 3 64 67 sky130_fd_pr__nfet_01v8__model L=0.15U W=1.14U AS=0.3306P AD=0.3306P PS=2.86U PD=2.86U
R10_1 3 4 15
R10_2 6 4 15
R10_3 5 7 576
C10_31 5 67 9.98634e-17
C10_32 7 67 9.98634e-17
R10_4 5 6 144
C10_41 5 67 2.9798e-17
C10_42 6 67 2.9798e-17
R10_5 2 3 144
C10_51 2 67 2.9798e-17
C10_52 3 67 2.9798e-17
R10_6 1 2 288
C10_61 1 67 5.15424e-17
C10_62 2 67 5.15424e-17
R9_1 10 13 15
R9_2 14 11 15
R9_3 16 11 15
R9_4 16 17 624
C9_41 16 67 1.05501e-16
C9_42 17 67 1.05501e-16
R9_5 15 16 192
C9_51 15 67 3.30194e-17
C9_52 16 67 3.30194e-17
R9_6 12 14 336
C9_61 12 67 5.79852e-17
C9_62 14 67 5.79852e-17
R9_7 13 11 65
C9_71 13 67 1.60722e-16
C9_72 11 67 1.60722e-16
R8_1 28 29 15
R8_2 25 24 15
R8_3 27 26 15
R8_4 32 30 15
R8_5 31 30 15
R8_6 22 21 15
R8_7 31 32 26
C8_71 31 67 7.50036e-17
C8_72 32 67 7.50036e-17
R8_8 26 31 78
C8_81 26 67 1.82152e-16
C8_82 31 67 1.82152e-16
R8_9 22 26 65
C8_91 22 67 1.50007e-16
C8_92 26 67 1.50007e-16
R8_10 25 27 384
C8_101 25 67 6.4428e-17
C8_102 27 67 6.4428e-17
R8_11 20 25 432
C8_111 20 67 7.65083e-17
C8_112 25 67 7.65083e-17
R8_12 23 24 39
C8_121 23 67 1.07148e-16
C8_122 24 67 1.07148e-16
R8_13 23 29 13
C8_131 23 67 3.21444e-17
C8_132 29 67 3.21444e-17
R7_1 37 35 15
R7_2 38 36 15
R7_3 38 39 26
C7_31 38 67 6.42888e-17
C7_32 39 67 6.42888e-17
R7_4 37 39 26
C7_41 37 67 6.42888e-17
C7_42 39 67 6.42888e-17
R6_1 50 43 15
R6_2 46 43 15
R6_3 44 43 15
R6_4 48 43 15
R6_5 49 42 15
R6_6 45 42 15
R6_7 47 42 15
R6_8 47 49 26
C6_81 47 67 6.42888e-17
C6_82 49 67 6.42888e-17
R6_9 45 47 13
C6_91 45 67 4.28592e-17
C6_92 47 67 4.28592e-17
R6_10 49 50 52
C6_101 49 67 1.28578e-16
C6_102 50 67 1.28578e-16
R6_11 48 50 26
C6_111 48 67 6.42888e-17
C6_112 50 67 6.42888e-17
R6_12 46 48 13
C6_121 46 67 5.3574e-17
C6_122 48 67 5.3574e-17
R6_13 44 46 13
C6_131 44 67 5.3574e-17
C6_132 46 67 5.3574e-17
R4_1 58 57 15
R4_2 59 57 15
R4_3 61 60 5
R4_4 56 61 26
C4_41 56 67 6.42888e-17
C4_42 61 67 6.42888e-17
R4_5 56 59 26
C4_51 56 67 6.42888e-17
C4_52 59 67 6.42888e-17
R4_6 56 58 26
C4_61 56 67 6.42888e-17
C4_62 58 67 6.42888e-17
R2_1 69 68 15
R2_2 71 70 15
R2_3 67 71 26
C2_31 67 67 6.42888e-17
C2_32 71 67 6.42888e-17
R2_4 67 69 26
C2_41 67 67 6.42888e-17
C2_42 69 67 6.42888e-17
R1_1 75 74 15
R1_2 83 80 15
R1_3 81 80 15
R1_4 78 77 15
R1_5 79 82 576
C1_51 79 67 1.03085e-16
C1_52 82 67 1.03085e-16
R1_6 76 79 384
C1_61 76 67 7.08708e-17
C1_62 79 67 7.08708e-17
R1_7 78 79 768
C1_71 78 67 1.35299e-16
C1_72 79 67 1.35299e-16
R1_8 81 83 26
C1_81 81 67 7.50036e-17
C1_82 83 67 7.50036e-17
R1_9 77 81 78
C1_91 77 67 1.82152e-16
C1_92 81 67 1.82152e-16
R1_10 75 77 65
C1_101 75 67 1.50007e-16
C1_102 77 67 1.50007e-16
.ends xr2_x1
