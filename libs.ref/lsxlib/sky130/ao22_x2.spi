* Spice description of ao22_x2
* Spice driver version -1787851859
* Date ( dd/mm/yyyy hh:mm:ss ):  8/05/2026 at 14:22:51

* INTERF i0 i1 i2 q vdd vss

.subckt ao22_x2 21 7 16 37 33 53
* NET 7 = i1
* NET 16 = i2
* NET 21 = i0
* NET 33 = vdd
* NET 37 = q
* NET 53 = vss
Mtr_00008 1 11 48 33 sky130_fd_pr__pfet_01v8__model L=0.15U W=1.26U AS=0.3654P AD=0.3654P PS=3.1U PD=3.1U
Mtr_00007 30 26 1 33 sky130_fd_pr__pfet_01v8__model L=0.15U W=1.26U AS=0.3654P AD=0.3654P PS=3.1U PD=3.1U
Mtr_00006 48 18 29 33 sky130_fd_pr__pfet_01v8__model L=0.15U W=1.26U AS=0.3654P AD=0.3654P PS=3.1U PD=3.1U
Mtr_00005 29 47 38 33 sky130_fd_pr__pfet_01v8__model L=0.15U W=2.46U AS=0.7134P AD=0.7134P PS=5.5U PD=5.5U
Mtr_00004 54 14 60 53 sky130_fd_pr__nfet_01v8__model L=0.15U W=0.66U AS=0.1914P AD=0.1914P PS=1.9U PD=1.9U
Mtr_00003 60 5 41 53 sky130_fd_pr__nfet_01v8__model L=0.15U W=0.66U AS=0.1914P AD=0.1914P PS=1.9U PD=1.9U
Mtr_00002 41 23 58 53 sky130_fd_pr__nfet_01v8__model L=0.15U W=0.66U AS=0.1914P AD=0.1914P PS=1.9U PD=1.9U
Mtr_00001 36 43 54 53 sky130_fd_pr__nfet_01v8__model L=0.15U W=1.26U AS=0.3654P AD=0.3654P PS=3.1U PD=3.1U
R8_1 8 7 15
R8_2 10 11 432
C8_21 10 53 7.40922e-17
C8_22 11 53 7.40922e-17
R8_3 9 10 48
C8_31 9 53 1.28856e-17
C8_32 10 53 1.28856e-17
R8_4 8 9 192
C8_41 8 53 3.86568e-17
C8_42 9 53 3.86568e-17
R8_5 4 8 336
C8_51 4 53 5.79852e-17
C8_52 8 53 5.79852e-17
R8_6 4 6 48
C8_61 4 53 1.28856e-17
C8_62 6 53 1.28856e-17
R8_7 5 6 240
C8_71 5 53 4.50996e-17
C8_72 6 53 4.50996e-17
R7_1 17 16 15
R7_2 14 15 15
R7_3 15 16 13
C7_31 15 53 3.21444e-17
C7_32 16 53 3.21444e-17
R7_4 17 18 672
C7_41 17 53 1.12749e-16
C7_42 18 53 1.12749e-16
R6_1 24 21 15
R6_2 22 23 48
C6_21 22 53 1.28856e-17
C6_22 23 53 1.28856e-17
R6_3 25 26 48
C6_31 25 53 1.28856e-17
C6_32 26 53 1.28856e-17
R6_4 24 25 384
C6_41 24 53 7.08708e-17
C6_42 25 53 7.08708e-17
R6_5 22 24 432
C6_51 22 53 7.73136e-17
C6_52 24 53 7.73136e-17
R5_1 32 29 15
R5_2 31 30 15
R5_3 31 33 26
C5_31 31 53 6.42888e-17
C5_32 33 53 6.42888e-17
R5_4 32 33 26
C5_41 32 53 6.42888e-17
C5_42 33 53 6.42888e-17
R4_1 36 37 7.5
R4_2 37 38 3.75
R3_1 42 41 15
R3_2 46 45 15
R3_3 49 48 15
R3_4 50 48 15
R3_5 46 47 672
C3_51 46 53 1.12749e-16
C3_52 47 53 1.12749e-16
R3_6 43 46 288
C3_61 43 53 5.47638e-17
C3_62 46 53 5.47638e-17
R3_7 49 50 13
C3_71 49 53 5.3574e-17
C3_72 50 53 5.3574e-17
R3_8 45 49 91
C3_81 45 53 2.19653e-16
C3_82 49 53 2.19653e-16
R3_9 44 45 13
C3_91 44 53 5.3574e-17
C3_92 45 53 5.3574e-17
R3_10 42 44 26
C3_101 42 53 6.42888e-17
C3_102 44 53 6.42888e-17
R2_1 55 54 15
R2_2 53 55 26
C2_21 53 53 6.42888e-17
C2_22 55 53 6.42888e-17
R1_1 61 60 15
R1_2 59 58 15
R1_3 59 61 52
C1_31 59 53 1.28578e-16
C1_32 61 53 1.28578e-16
.ends ao22_x2
