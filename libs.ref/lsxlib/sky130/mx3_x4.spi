* Spice description of mx3_x4
* Spice driver version -1580926035
* Date ( dd/mm/yyyy hh:mm:ss ):  8/05/2026 at 14:22:51

* INTERF cmd0 cmd1 i0 i1 i2 q vdd vss

.subckt mx3_x4 16 65 29 77 59 36 94 130
* NET 16 = cmd0
* NET 29 = i0
* NET 36 = q
* NET 59 = i2
* NET 65 = cmd1
* NET 77 = i1
* NET 94 = vdd
* NET 130 = vss
Mtr_00022 85 120 37 94 sky130_fd_pr__pfet_01v8__model L=0.15U W=2.46U AS=0.7134P AD=0.7134P PS=5.5U PD=5.5U
Mtr_00021 37 121 84 94 sky130_fd_pr__pfet_01v8__model L=0.15U W=2.46U AS=0.7134P AD=0.7134P PS=5.5U PD=5.5U
Mtr_00020 84 23 52 94 sky130_fd_pr__pfet_01v8__model L=0.15U W=0.78U AS=0.2262P AD=0.2262P PS=2.14U PD=2.14U
Mtr_00019 146 67 83 94 sky130_fd_pr__pfet_01v8__model L=0.15U W=0.78U AS=0.2262P AD=0.2262P PS=2.14U PD=2.14U
Mtr_00018 125 32 1 94 sky130_fd_pr__pfet_01v8__model L=0.15U W=1.14U AS=0.3306P AD=0.3306P PS=2.86U PD=2.86U
Mtr_00017 13 61 7 94 sky130_fd_pr__pfet_01v8__model L=0.15U W=1.14U AS=0.3306P AD=0.3306P PS=2.86U PD=2.86U
Mtr_00016 122 73 13 94 sky130_fd_pr__pfet_01v8__model L=0.15U W=1.14U AS=0.3306P AD=0.3306P PS=2.86U PD=2.86U
Mtr_00015 4 149 122 94 sky130_fd_pr__pfet_01v8__model L=0.15U W=1.14U AS=0.3306P AD=0.3306P PS=2.86U PD=2.86U
Mtr_00014 1 24 88 94 sky130_fd_pr__pfet_01v8__model L=0.15U W=1.14U AS=0.3306P AD=0.3306P PS=2.86U PD=2.86U
Mtr_00013 88 54 8 94 sky130_fd_pr__pfet_01v8__model L=0.15U W=1.14U AS=0.3306P AD=0.3306P PS=2.86U PD=2.86U
Mtr_00012 8 80 4 94 sky130_fd_pr__pfet_01v8__model L=0.15U W=1.14U AS=0.3306P AD=0.3306P PS=2.86U PD=2.86U
Mtr_00011 137 116 35 130 sky130_fd_pr__nfet_01v8__model L=0.15U W=1.26U AS=0.3654P AD=0.3654P PS=3.1U PD=3.1U
Mtr_00010 35 117 135 130 sky130_fd_pr__nfet_01v8__model L=0.15U W=1.26U AS=0.3654P AD=0.3654P PS=3.1U PD=3.1U
Mtr_00009 46 21 135 130 sky130_fd_pr__nfet_01v8__model L=0.15U W=0.42U AS=0.1218P AD=0.1218P PS=1.42U PD=1.42U
Mtr_00008 112 28 40 130 sky130_fd_pr__nfet_01v8__model L=0.15U W=0.54U AS=0.1566P AD=0.1566P PS=1.66U PD=1.66U
Mtr_00007 133 17 99 130 sky130_fd_pr__nfet_01v8__model L=0.15U W=0.54U AS=0.1566P AD=0.1566P PS=1.66U PD=1.66U
Mtr_00006 40 44 133 130 sky130_fd_pr__nfet_01v8__model L=0.15U W=0.54U AS=0.1566P AD=0.1566P PS=1.66U PD=1.66U
Mtr_00005 131 64 142 130 sky130_fd_pr__nfet_01v8__model L=0.15U W=0.42U AS=0.1218P AD=0.1218P PS=1.42U PD=1.42U
Mtr_00004 106 58 97 130 sky130_fd_pr__nfet_01v8__model L=0.15U W=0.54U AS=0.1566P AD=0.1566P PS=1.66U PD=1.66U
Mtr_00003 103 66 109 130 sky130_fd_pr__nfet_01v8__model L=0.15U W=0.54U AS=0.1566P AD=0.1566P PS=1.66U PD=1.66U
Mtr_00002 109 144 106 130 sky130_fd_pr__nfet_01v8__model L=0.15U W=0.54U AS=0.1566P AD=0.1566P PS=1.66U PD=1.66U
Mtr_00001 99 78 103 130 sky130_fd_pr__nfet_01v8__model L=0.15U W=0.54U AS=0.1566P AD=0.1566P PS=1.66U PD=1.66U
R17_1 9 7 15
R17_2 10 8 15
R17_3 9 10 104
C17_31 9 130 2.4644e-16
C17_32 10 130 2.4644e-16
R15_1 22 16 15
R15_2 17 18 48
C15_21 17 130 1.28856e-17
C15_22 18 130 1.28856e-17
R15_3 18 19 192
C15_31 18 130 3.86568e-17
C15_32 19 130 3.86568e-17
R15_4 19 20 48
C15_41 19 130 1.28856e-17
C15_42 20 130 1.28856e-17
R15_5 25 24 48
C15_51 25 130 1.28856e-17
C15_52 24 130 1.28856e-17
R15_6 22 25 384
C15_61 22 130 6.4428e-17
C15_62 25 130 6.4428e-17
R15_7 20 22 336
C15_71 20 130 5.79852e-17
C15_72 22 130 5.79852e-17
R15_8 21 23 576
C15_81 21 130 1.0389e-16
C15_82 23 130 1.0389e-16
R15_9 22 23 528
C15_91 22 130 8.93939e-17
C15_92 23 130 8.93939e-17
R14_1 30 29 15
R14_2 31 29 15
R14_3 31 32 384
C14_31 31 130 7.00654e-17
C14_32 32 130 7.00654e-17
R14_4 28 30 528
C14_41 28 130 9.26153e-17
C14_42 30 130 9.26153e-17
R13_1 36 35 7.5
R13_2 36 37 3.75
R11_1 51 46 15
R11_2 53 52 15
R11_3 44 45 15
R11_4 49 48 15
R11_5 55 54 48
C11_51 55 130 1.28856e-17
C11_52 54 130 1.28856e-17
R11_6 49 55 720
C11_61 49 130 1.22413e-16
C11_62 55 130 1.22413e-16
R11_7 43 48 13
C11_71 43 130 5.3574e-17
C11_72 48 130 5.3574e-17
R11_8 45 47 13
C11_81 45 130 4.28592e-17
C11_82 47 130 4.28592e-17
R11_9 43 45 26
C11_91 43 130 8.57184e-17
C11_92 45 130 8.57184e-17
R11_10 47 50 13
C11_101 47 130 5.3574e-17
C11_102 50 130 5.3574e-17
R11_11 50 51 13
C11_111 50 130 4.28592e-17
C11_112 51 130 4.28592e-17
R11_12 51 53 52
C11_121 51 130 1.39292e-16
C11_122 53 130 1.39292e-16
R10_1 60 59 15
R10_2 60 61 768
C10_21 60 130 1.28856e-16
C10_22 61 130 1.28856e-16
R10_3 58 60 528
C10_31 58 130 9.34206e-17
C10_32 60 130 9.34206e-17
R9_1 68 65 15
R9_2 73 74 15
R9_3 66 72 384
C9_31 66 130 6.76494e-17
C9_32 72 130 6.76494e-17
R9_4 69 72 192
C9_41 69 130 3.2214e-17
C9_42 72 130 3.2214e-17
R9_5 69 70 288
C9_51 69 130 5.15424e-17
C9_52 70 130 5.15424e-17
R9_6 71 70 48
C9_61 71 130 1.28856e-17
C9_62 70 130 1.28856e-17
R9_7 71 73 528
C9_71 71 130 9.50313e-17
C9_72 73 130 9.50313e-17
R9_8 65 74 52
C9_81 65 130 1.28578e-16
C9_82 74 130 1.28578e-16
R9_9 68 67 288
C9_91 68 130 4.8321e-17
C9_92 67 130 4.8321e-17
R9_10 64 68 288
C9_101 64 130 5.15424e-17
C9_102 68 130 5.15424e-17
R8_1 79 77 15
R8_2 79 80 768
C8_21 79 130 1.28856e-16
C8_22 80 130 1.28856e-16
R8_3 78 79 528
C8_31 78 130 9.34206e-17
C8_32 79 130 9.34206e-17
R7_1 90 83 15
R7_2 89 85 15
R7_3 93 85 15
R7_4 87 85 15
R7_5 86 85 15
R7_6 91 88 15
R7_7 92 84 15
R7_8 92 94 26
C7_81 92 130 6.42888e-17
C7_82 94 130 6.42888e-17
R7_9 91 94 26
C7_91 91 130 6.42888e-17
C7_92 94 130 6.42888e-17
R7_10 93 94 26
C7_101 93 130 6.42888e-17
C7_102 94 130 6.42888e-17
R7_11 89 93 13
C7_111 89 130 5.3574e-17
C7_112 93 130 5.3574e-17
R7_12 87 89 26
C7_121 87 130 6.42888e-17
C7_122 89 130 6.42888e-17
R7_13 86 87 26
C7_131 86 130 6.42888e-17
C7_132 87 130 6.42888e-17
R7_14 90 94 26
C7_141 90 130 6.42888e-17
C7_142 94 130 6.42888e-17
R6_1 98 97 15
R6_2 100 99 15
R6_3 98 100 104
C6_31 98 130 2.4644e-16
C6_32 100 130 2.4644e-16
R3_1 110 109 15
R3_2 126 125 15
R3_3 123 122 15
R3_4 119 118 15
R3_5 114 112 15
R3_6 119 121 528
C3_61 119 130 9.34206e-17
C3_62 121 130 9.34206e-17
R3_7 117 119 432
C3_71 117 130 7.40922e-17
C3_72 119 130 7.40922e-17
R3_8 119 120 528
C3_81 119 130 9.34206e-17
C3_82 120 130 9.34206e-17
R3_9 116 119 432
C3_91 116 130 7.40922e-17
C3_92 119 130 7.40922e-17
R3_10 114 113 13
C3_101 114 130 5.3574e-17
C3_102 113 130 5.3574e-17
R3_11 113 115 13
C3_111 113 130 5.3574e-17
C3_112 115 130 5.3574e-17
R3_12 118 127 78
C3_121 118 130 1.92866e-16
C3_122 127 130 1.92866e-16
R3_13 115 118 39
C3_131 115 130 1.07148e-16
C3_132 118 130 1.07148e-16
R3_14 126 127 26
C3_141 126 130 6.42888e-17
C3_142 127 130 6.42888e-17
R3_15 124 126 91
C3_151 124 130 2.25011e-16
C3_152 126 130 2.25011e-16
R3_16 123 124 26
C3_161 123 130 7.50036e-17
C3_162 124 130 7.50036e-17
R3_17 111 124 130
C3_171 111 130 3.00014e-16
C3_172 124 130 3.00014e-16
R3_18 110 111 26
C3_181 110 130 7.50036e-17
C3_182 111 130 7.50036e-17
R2_1 132 131 15
R2_2 139 137 15
R2_3 138 137 15
R2_4 136 135 15
R2_5 134 133 15
R2_6 130 134 26
C2_61 130 130 6.42888e-17
C2_62 134 130 6.42888e-17
R2_7 130 136 26
C2_71 130 130 6.42888e-17
C2_72 136 130 6.42888e-17
R2_8 138 139 26
C2_81 138 130 7.50036e-17
C2_82 139 130 7.50036e-17
R2_9 130 138 26
C2_91 130 130 6.42888e-17
C2_92 138 130 6.42888e-17
R2_10 130 132 26
C2_101 130 130 6.42888e-17
C2_102 132 130 6.42888e-17
R1_1 143 142 15
R1_2 144 145 15
R1_3 147 146 15
R1_4 149 150 15
R1_5 148 150 13
C1_51 148 130 5.3574e-17
C1_52 150 130 5.3574e-17
R1_6 147 148 65
C1_61 147 130 1.50007e-16
C1_62 148 130 1.50007e-16
R1_7 143 147 65
C1_71 143 130 1.71437e-16
C1_72 147 130 1.71437e-16
R1_8 143 145 26
C1_81 143 130 7.50036e-17
C1_82 145 130 7.50036e-17
.ends mx3_x4
