* Spice description of noa2a22_x4
* Spice driver version 688708525
* Date ( dd/mm/yyyy hh:mm:ss ):  8/05/2026 at 14:23:17

* INTERF i0 i1 i2 i3 nq vdd vss

.subckt noa2a22_x4 52 46 59 65 28 24 90
* NET 24 = vdd
* NET 28 = nq
* NET 46 = i1
* NET 52 = i0
* NET 59 = i2
* NET 65 = i3
* NET 90 = vss
Mtr_00014 18 67 2 24 sky130_fd_pr__pfet_01v8__model L=0.15U W=1.26U AS=0.3654P AD=0.3654P PS=3.1U PD=3.1U
Mtr_00013 3 61 18 24 sky130_fd_pr__pfet_01v8__model L=0.15U W=1.26U AS=0.3654P AD=0.3654P PS=3.1U PD=3.1U
Mtr_00012 2 49 80 24 sky130_fd_pr__pfet_01v8__model L=0.15U W=1.26U AS=0.3654P AD=0.3654P PS=3.1U PD=3.1U
Mtr_00011 80 55 1 24 sky130_fd_pr__pfet_01v8__model L=0.15U W=1.26U AS=0.3654P AD=0.3654P PS=3.1U PD=3.1U
Mtr_00010 41 84 12 24 sky130_fd_pr__pfet_01v8__model L=0.15U W=1.26U AS=0.3654P AD=0.3654P PS=3.1U PD=3.1U
Mtr_00009 29 40 14 24 sky130_fd_pr__pfet_01v8__model L=0.15U W=2.46U AS=0.7134P AD=0.7134P PS=5.5U PD=5.5U
Mtr_00008 12 39 29 24 sky130_fd_pr__pfet_01v8__model L=0.15U W=2.46U AS=0.7134P AD=0.7134P PS=5.5U PD=5.5U
Mtr_00007 70 58 93 90 sky130_fd_pr__nfet_01v8__model L=0.15U W=0.66U AS=0.1914P AD=0.1914P PS=1.9U PD=1.9U
Mtr_00006 73 64 70 90 sky130_fd_pr__nfet_01v8__model L=0.15U W=0.66U AS=0.1914P AD=0.1914P PS=1.9U PD=1.9U
Mtr_00005 87 47 73 90 sky130_fd_pr__nfet_01v8__model L=0.15U W=0.66U AS=0.1914P AD=0.1914P PS=1.9U PD=1.9U
Mtr_00004 91 53 87 90 sky130_fd_pr__nfet_01v8__model L=0.15U W=0.66U AS=0.1914P AD=0.1914P PS=1.9U PD=1.9U
Mtr_00003 95 77 32 90 sky130_fd_pr__nfet_01v8__model L=0.15U W=0.66U AS=0.1914P AD=0.1914P PS=1.9U PD=1.9U
Mtr_00002 27 34 95 90 sky130_fd_pr__nfet_01v8__model L=0.15U W=1.26U AS=0.3654P AD=0.3654P PS=3.1U PD=3.1U
Mtr_00001 97 35 27 90 sky130_fd_pr__nfet_01v8__model L=0.15U W=1.26U AS=0.3654P AD=0.3654P PS=3.1U PD=3.1U
R12_1 8 2 15
R12_2 5 2 15
R12_3 7 1 15
R12_4 6 3 15
R12_5 4 1 15
R12_6 9 3 15
R12_7 6 9 13
C12_71 6 90 5.3574e-17
C12_72 9 90 5.3574e-17
R12_8 4 7 13
C12_81 4 90 5.3574e-17
C12_82 7 90 5.3574e-17
R12_9 5 6 52
C12_91 5 90 1.28578e-16
C12_92 6 90 1.28578e-16
R12_10 7 8 52
C12_101 7 90 1.28578e-16
C12_102 8 90 1.28578e-16
R12_11 5 8 13
C12_111 5 90 5.3574e-17
C12_112 8 90 5.3574e-17
R11_1 17 14 15
R11_2 20 14 15
R11_3 23 14 15
R11_4 14 15 15
R11_5 22 12 15
R11_6 19 12 15
R11_7 16 12 15
R11_8 13 12 15
R11_9 21 18 15
R11_10 21 24 26
C11_101 21 90 6.42888e-17
C11_102 24 90 6.42888e-17
R11_11 22 24 26
C11_111 22 90 6.42888e-17
C11_112 24 90 6.42888e-17
R11_12 19 22 26
C11_121 19 90 6.42888e-17
C11_122 22 90 6.42888e-17
R11_13 16 19 26
C11_131 16 90 6.42888e-17
C11_132 19 90 6.42888e-17
R11_14 13 16 13
C11_141 13 90 5.3574e-17
C11_142 16 90 5.3574e-17
R11_15 23 24 26
C11_151 23 90 6.42888e-17
C11_152 24 90 6.42888e-17
R11_16 20 23 26
C11_161 20 90 6.42888e-17
C11_162 23 90 6.42888e-17
R11_17 17 20 26
C11_171 17 90 6.42888e-17
C11_172 20 90 6.42888e-17
R11_18 15 17 13
C11_181 15 90 5.3574e-17
C11_182 17 90 5.3574e-17
R10_1 28 27 7.5
R10_2 28 29 3.75
R9_1 33 32 15
R9_2 42 41 15
R9_3 43 41 15
R9_4 38 37 15
R9_5 38 40 528
C9_51 38 90 9.34206e-17
C9_52 40 90 9.34206e-17
R9_6 35 38 432
C9_61 35 90 7.40922e-17
C9_62 38 90 7.40922e-17
R9_7 38 39 528
C9_71 38 90 9.34206e-17
C9_72 39 90 9.34206e-17
R9_8 34 38 432
C9_81 34 90 7.40922e-17
C9_82 38 90 7.40922e-17
R9_9 36 37 26
C9_91 36 90 6.42888e-17
C9_92 37 90 6.42888e-17
R9_10 42 43 26
C9_101 42 90 7.50036e-17
C9_102 43 90 7.50036e-17
R9_11 36 42 65
C9_111 36 90 1.71437e-16
C9_112 42 90 1.71437e-16
R9_12 33 36 65
C9_121 33 90 1.60722e-16
C9_122 36 90 1.60722e-16
R8_1 48 46 15
R8_2 48 49 720
C8_21 48 90 1.25635e-16
C8_22 49 90 1.25635e-16
R8_3 47 48 528
C8_31 47 90 9.01992e-17
C8_32 48 90 9.01992e-17
R7_1 54 52 15
R7_2 54 55 720
C7_21 54 90 1.25635e-16
C7_22 55 90 1.25635e-16
R7_3 53 54 528
C7_31 53 90 9.01992e-17
C7_32 54 90 9.01992e-17
R6_1 60 59 15
R6_2 60 61 720
C6_21 60 90 1.25635e-16
C6_22 61 90 1.25635e-16
R6_3 58 60 528
C6_31 58 90 9.01992e-17
C6_32 60 90 9.01992e-17
R5_1 66 65 15
R5_2 66 67 720
C5_21 66 90 1.25635e-16
C5_22 67 90 1.25635e-16
R5_3 64 66 528
C5_31 64 90 9.01992e-17
C5_32 66 90 9.01992e-17
R3_1 74 73 15
R3_2 82 80 15
R3_3 79 78 15
R3_4 79 84 720
C3_41 79 90 1.25635e-16
C3_42 84 90 1.25635e-16
R3_5 77 79 528
C3_51 77 90 9.01992e-17
C3_52 79 90 9.01992e-17
R3_6 76 78 39
C3_61 76 90 1.07148e-16
C3_62 78 90 1.07148e-16
R3_7 81 82 13
C3_71 81 90 5.3574e-17
C3_72 82 90 5.3574e-17
R3_8 75 76 65
C3_81 75 90 1.60722e-16
C3_82 76 90 1.60722e-16
R3_9 81 83 26
C3_91 81 90 6.42888e-17
C3_92 83 90 6.42888e-17
R3_10 75 83 104
C3_101 75 90 2.4644e-16
C3_102 83 90 2.4644e-16
R3_11 74 75 13
C3_111 74 90 5.3574e-17
C3_112 75 90 5.3574e-17
R1_1 92 91 15
R1_2 98 97 15
R1_3 100 97 15
R1_4 96 95 15
R1_5 99 95 15
R1_6 94 93 15
R1_7 90 94 26
C1_71 90 90 6.42888e-17
C1_72 94 90 6.42888e-17
R1_8 96 99 26
C1_81 96 90 7.50036e-17
C1_82 99 90 7.50036e-17
R1_9 90 96 26
C1_91 90 90 6.42888e-17
C1_92 96 90 6.42888e-17
R1_10 98 100 26
C1_101 98 90 7.50036e-17
C1_102 100 90 7.50036e-17
R1_11 90 98 26
C1_111 90 90 6.42888e-17
C1_112 98 90 6.42888e-17
R1_12 90 92 26
C1_121 90 90 6.42888e-17
C1_122 92 90 6.42888e-17
.ends noa2a22_x4
