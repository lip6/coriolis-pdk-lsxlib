* Spice description of o2_x4
* Spice driver version -1455600723
* Date ( dd/mm/yyyy hh:mm:ss ):  8/05/2026 at 14:22:51

* INTERF i0 i1 q vdd vss

.subckt o2_x4 12 4 30 26 49
* NET 4 = i1
* NET 12 = i0
* NET 26 = vdd
* NET 30 = q
* NET 49 = vss
Mtr_00008 31 44 20 26 sky130_fd_pr__pfet_01v8__model L=0.15U W=2.46U AS=0.7134P AD=0.7134P PS=5.5U PD=5.5U
Mtr_00007 31 43 19 26 sky130_fd_pr__pfet_01v8__model L=0.15U W=2.22U AS=0.6438P AD=0.6438P PS=5.02U PD=5.02U
Mtr_00006 19 15 1 26 sky130_fd_pr__pfet_01v8__model L=0.15U W=1.98U AS=0.5742P AD=0.5742P PS=4.54U PD=4.54U
Mtr_00005 1 9 42 26 sky130_fd_pr__pfet_01v8__model L=0.15U W=1.98U AS=0.5742P AD=0.5742P PS=4.54U PD=4.54U
Mtr_00004 54 37 29 49 sky130_fd_pr__nfet_01v8__model L=0.15U W=1.26U AS=0.3654P AD=0.3654P PS=3.1U PD=3.1U
Mtr_00003 50 6 34 49 sky130_fd_pr__nfet_01v8__model L=0.15U W=0.66U AS=0.1914P AD=0.1914P PS=1.9U PD=1.9U
Mtr_00002 34 13 52 49 sky130_fd_pr__nfet_01v8__model L=0.15U W=0.66U AS=0.1914P AD=0.1914P PS=1.9U PD=1.9U
Mtr_00001 29 36 52 49 sky130_fd_pr__nfet_01v8__model L=0.15U W=1.26U AS=0.3654P AD=0.3654P PS=3.1U PD=3.1U
R6_1 7 4 15
R6_2 8 9 48
C6_21 8 49 1.28856e-17
C6_22 9 49 1.28856e-17
R6_3 7 8 288
C6_31 7 49 5.15424e-17
C6_32 8 49 5.15424e-17
R6_4 5 7 336
C6_41 5 49 5.79852e-17
C6_42 7 49 5.79852e-17
R6_5 5 6 48
C6_51 5 49 1.28856e-17
C6_52 6 49 1.28856e-17
R5_1 16 12 15
R5_2 14 12 15
R5_3 13 14 336
C5_31 13 49 6.36227e-17
C5_32 14 49 6.36227e-17
R5_4 16 15 480
C5_41 16 49 8.0535e-17
C5_42 15 49 8.0535e-17
R4_1 20 25 15
R4_2 20 21 15
R4_3 20 22 15
R4_4 20 23 15
R4_5 24 19 15
R4_6 24 26 26
C4_61 24 49 6.42888e-17
C4_62 26 49 6.42888e-17
R4_7 25 26 26
C4_71 25 49 6.42888e-17
C4_72 26 49 6.42888e-17
R4_8 23 25 13
C4_81 23 49 5.3574e-17
C4_82 25 49 5.3574e-17
R4_9 22 23 26
C4_91 22 49 6.42888e-17
C4_92 23 49 6.42888e-17
R4_10 21 22 26
C4_101 21 49 6.42888e-17
C4_102 22 49 6.42888e-17
R3_1 30 29 7.5
R3_2 30 31 3.75
R2_1 35 34 15
R2_2 39 38 15
R2_3 45 42 15
R2_4 41 44 528
C2_41 41 49 9.34206e-17
C2_42 44 49 9.34206e-17
R2_5 37 41 432
C2_51 37 49 7.40922e-17
C2_52 41 49 7.40922e-17
R2_6 40 43 576
C2_61 40 49 9.98634e-17
C2_62 43 49 9.98634e-17
R2_7 36 40 432
C2_71 36 49 7.40922e-17
C2_72 40 49 7.40922e-17
R2_8 40 41 192
C2_81 40 49 3.86568e-17
C2_82 41 49 3.86568e-17
R2_9 39 40 336
C2_91 39 49 5.79852e-17
C2_92 40 49 5.79852e-17
R2_10 45 46 26
C2_101 45 49 6.42888e-17
C2_102 46 49 6.42888e-17
R2_11 38 46 104
C2_111 38 49 2.57155e-16
C2_112 46 49 2.57155e-16
R2_12 35 38 65
C2_121 35 49 1.50007e-16
C2_122 38 49 1.50007e-16
R1_1 51 50 15
R1_2 56 54 15
R1_3 55 54 15
R1_4 53 52 7.5
R1_5 49 53 26
C1_51 49 49 6.42888e-17
C1_52 53 49 6.42888e-17
R1_6 55 56 26
C1_61 55 49 6.42888e-17
C1_62 56 49 6.42888e-17
R1_7 49 55 26
C1_71 49 49 6.42888e-17
C1_72 55 49 6.42888e-17
R1_8 49 51 26
C1_81 49 49 6.42888e-17
C1_82 51 49 6.42888e-17
.ends o2_x4
