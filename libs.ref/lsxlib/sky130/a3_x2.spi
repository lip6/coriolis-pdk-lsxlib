* Spice description of a3_x2
* Spice driver version 364034989
* Date ( dd/mm/yyyy hh:mm:ss ):  8/05/2026 at 14:22:51

* INTERF i0 i1 i2 q vdd vss

.subckt a3_x2 8 2 13 27 23 34
* NET 2 = i1
* NET 8 = i0
* NET 13 = i2
* NET 23 = vdd
* NET 27 = q
* NET 34 = vss
Mtr_00008 53 16 20 23 sky130_fd_pr__pfet_01v8__model L=0.15U W=1.26U AS=0.3654P AD=0.3654P PS=3.1U PD=3.1U
Mtr_00007 28 50 19 23 sky130_fd_pr__pfet_01v8__model L=0.15U W=2.46U AS=0.7134P AD=0.7134P PS=5.5U PD=5.5U
Mtr_00006 51 10 19 23 sky130_fd_pr__pfet_01v8__model L=0.15U W=1.26U AS=0.3654P AD=0.3654P PS=3.1U PD=3.1U
Mtr_00005 20 4 51 23 sky130_fd_pr__pfet_01v8__model L=0.15U W=1.26U AS=0.3654P AD=0.3654P PS=3.1U PD=3.1U
Mtr_00004 31 14 45 34 sky130_fd_pr__nfet_01v8__model L=0.15U W=1.26U AS=0.3654P AD=0.3654P PS=3.1U PD=3.1U
Mtr_00003 35 43 26 34 sky130_fd_pr__nfet_01v8__model L=0.15U W=1.26U AS=0.3654P AD=0.3654P PS=3.1U PD=3.1U
Mtr_00002 40 1 31 34 sky130_fd_pr__nfet_01v8__model L=0.15U W=1.26U AS=0.3654P AD=0.3654P PS=3.1U PD=3.1U
Mtr_00001 35 7 40 34 sky130_fd_pr__nfet_01v8__model L=0.15U W=1.26U AS=0.3654P AD=0.3654P PS=3.1U PD=3.1U
R9_1 3 2 15
R9_2 3 4 672
C9_21 3 34 1.12749e-16
C9_22 4 34 1.12749e-16
R9_3 1 3 480
C9_31 1 34 8.69778e-17
C9_32 3 34 8.69778e-17
R8_1 9 8 15
R8_2 9 10 672
C8_21 9 34 1.12749e-16
C8_22 10 34 1.12749e-16
R8_3 7 9 480
C8_31 7 34 8.69778e-17
C8_32 9 34 8.69778e-17
R7_1 15 13 15
R7_2 15 16 672
C7_21 15 34 1.12749e-16
C7_22 16 34 1.12749e-16
R7_3 14 15 480
C7_31 14 34 8.69778e-17
C7_32 15 34 8.69778e-17
R6_1 21 19 15
R6_2 22 20 15
R6_3 22 23 26
C6_31 22 34 6.42888e-17
C6_32 23 34 6.42888e-17
R6_4 21 23 26
C6_41 21 34 6.42888e-17
C6_42 23 34 6.42888e-17
R5_1 27 26 7.5
R5_2 27 28 3.75
R3_1 37 35 15
R3_2 36 35 15
R3_3 36 37 26
C3_31 36 34 7.50036e-17
C3_32 37 34 7.50036e-17
R3_4 34 36 26
C3_41 34 34 6.42888e-17
C3_42 36 34 6.42888e-17
R1_1 45 46 15
R1_2 52 51 15
R1_3 55 51 15
R1_4 48 47 15
R1_5 56 53 15
R1_6 48 50 672
C1_61 48 34 1.12749e-16
C1_62 50 34 1.12749e-16
R1_7 43 48 288
C1_71 43 34 5.47638e-17
C1_72 48 34 5.47638e-17
R1_8 54 56 13
C1_81 54 34 5.3574e-17
C1_82 56 34 5.3574e-17
R1_9 47 49 26
C1_91 47 34 7.50036e-17
C1_92 49 34 7.50036e-17
R1_10 52 54 52
C1_101 52 34 1.28578e-16
C1_102 54 34 1.28578e-16
R1_11 52 55 26
C1_111 52 34 6.42888e-17
C1_112 55 34 6.42888e-17
R1_12 49 52 91
C1_121 49 34 2.14296e-16
C1_122 52 34 2.14296e-16
R1_13 44 49 52
C1_131 44 34 1.28578e-16
C1_132 49 34 1.28578e-16
R1_14 44 46 52
C1_141 44 34 1.28578e-16
C1_142 46 34 1.28578e-16
.ends a3_x2
