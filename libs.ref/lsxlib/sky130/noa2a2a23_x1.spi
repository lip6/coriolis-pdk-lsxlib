* Spice description of noa2a2a23_x1
* Spice driver version 274398125
* Date ( dd/mm/yyyy hh:mm:ss ):  8/05/2026 at 14:22:51

* INTERF i0 i1 i2 i3 i4 i5 nq vdd vss

.subckt noa2a2a23_x1 26 44 33 39 2 8 72 20 84
* NET 2 = i4
* NET 8 = i5
* NET 20 = vdd
* NET 26 = i0
* NET 33 = i2
* NET 39 = i3
* NET 44 = i1
* NET 72 = nq
* NET 84 = vss
Mtr_00012 14 3 51 20 sky130_fd_pr__pfet_01v8__model L=0.15U W=2.46U AS=0.7134P AD=0.7134P PS=5.5U PD=5.5U
Mtr_00011 51 9 13 20 sky130_fd_pr__pfet_01v8__model L=0.15U W=2.46U AS=0.7134P AD=0.7134P PS=5.5U PD=5.5U
Mtr_00010 76 29 58 20 sky130_fd_pr__pfet_01v8__model L=0.15U W=2.46U AS=0.7134P AD=0.7134P PS=5.5U PD=5.5U
Mtr_00009 50 40 59 20 sky130_fd_pr__pfet_01v8__model L=0.15U W=2.46U AS=0.7134P AD=0.7134P PS=5.5U PD=5.5U
Mtr_00008 60 34 50 20 sky130_fd_pr__pfet_01v8__model L=0.15U W=2.46U AS=0.7134P AD=0.7134P PS=5.5U PD=5.5U
Mtr_00007 59 47 76 20 sky130_fd_pr__pfet_01v8__model L=0.15U W=2.46U AS=0.7134P AD=0.7134P PS=5.5U PD=5.5U
Mtr_00006 68 32 87 84 sky130_fd_pr__nfet_01v8__model L=0.15U W=1.26U AS=0.3654P AD=0.3654P PS=3.1U PD=3.1U
Mtr_00005 71 38 68 84 sky130_fd_pr__nfet_01v8__model L=0.15U W=1.26U AS=0.3654P AD=0.3654P PS=3.1U PD=3.1U
Mtr_00004 81 45 71 84 sky130_fd_pr__nfet_01v8__model L=0.15U W=1.26U AS=0.3654P AD=0.3654P PS=3.1U PD=3.1U
Mtr_00003 85 27 81 84 sky130_fd_pr__nfet_01v8__model L=0.15U W=1.26U AS=0.3654P AD=0.3654P PS=3.1U PD=3.1U
Mtr_00002 73 7 23 84 sky130_fd_pr__nfet_01v8__model L=0.15U W=1.26U AS=0.3654P AD=0.3654P PS=3.1U PD=3.1U
Mtr_00001 23 1 89 84 sky130_fd_pr__nfet_01v8__model L=0.15U W=1.26U AS=0.3654P AD=0.3654P PS=3.1U PD=3.1U
R14_1 4 2 15
R14_2 4 3 528
C14_21 4 84 9.34206e-17
C14_22 3 84 9.34206e-17
R14_3 1 4 432
C14_31 1 84 7.40922e-17
C14_32 4 84 7.40922e-17
R13_1 10 8 15
R13_2 10 9 528
C13_21 10 84 9.34206e-17
C13_22 9 84 9.34206e-17
R13_3 7 10 432
C13_31 7 84 7.40922e-17
C13_32 10 84 7.40922e-17
R12_1 15 13 15
R12_2 18 13 15
R12_3 16 14 15
R12_4 17 14 15
R12_5 19 14 15
R12_6 19 20 26
C12_61 19 84 6.42888e-17
C12_62 20 84 6.42888e-17
R12_7 17 19 13
C12_71 17 84 5.3574e-17
C12_72 19 84 5.3574e-17
R12_8 16 17 13
C12_81 16 84 5.3574e-17
C12_82 17 84 5.3574e-17
R12_9 18 20 26
C12_91 18 84 6.42888e-17
C12_92 20 84 6.42888e-17
R12_10 15 16 52
C12_101 15 84 1.28578e-16
C12_102 16 84 1.28578e-16
R10_1 28 26 15
R10_2 28 29 528
C10_21 28 84 9.34206e-17
C10_22 29 84 9.34206e-17
R10_3 27 28 432
C10_31 27 84 7.40922e-17
C10_32 28 84 7.40922e-17
R9_1 35 33 15
R9_2 35 34 528
C9_21 35 84 9.34206e-17
C9_22 34 84 9.34206e-17
R9_3 32 35 432
C9_31 32 84 7.40922e-17
C9_32 35 84 7.40922e-17
R8_1 41 39 15
R8_2 41 40 528
C8_21 41 84 9.34206e-17
C8_22 40 84 9.34206e-17
R8_3 38 41 432
C8_31 38 84 7.40922e-17
C8_32 41 84 7.40922e-17
R7_1 46 44 15
R7_2 46 47 528
C7_21 46 84 9.34206e-17
C7_22 47 84 9.34206e-17
R7_3 45 46 432
C7_31 45 84 7.40922e-17
C7_32 46 84 7.40922e-17
R6_1 52 50 15
R6_2 53 50 15
R6_3 54 51 15
R6_4 55 51 15
R6_5 54 55 13
C6_51 54 84 5.3574e-17
C6_52 55 84 5.3574e-17
R6_6 53 54 78
C6_61 53 84 1.92866e-16
C6_62 54 84 1.92866e-16
R6_7 52 53 13
C6_71 52 84 5.3574e-17
C6_72 53 84 5.3574e-17
R5_1 65 60 15
R5_2 63 58 15
R5_3 64 59 15
R5_4 61 58 15
R5_5 62 59 15
R5_6 62 64 13
C5_61 62 84 5.3574e-17
C5_62 64 84 5.3574e-17
R5_7 61 63 13
C5_71 61 84 5.3574e-17
C5_72 63 84 5.3574e-17
R5_8 64 65 52
C5_81 64 84 1.28578e-16
C5_82 65 84 1.28578e-16
R5_9 63 64 52
C5_91 63 84 1.28578e-16
C5_92 64 84 1.28578e-16
R3_1 72 71 7.5
R3_2 74 73 15
R3_3 75 73 15
R3_4 77 76 15
R3_5 78 76 15
R3_6 77 78 13
C3_61 77 84 5.3574e-17
C3_62 78 84 5.3574e-17
R3_7 77 72 26
C3_71 77 84 6.42888e-17
C3_72 72 84 6.42888e-17
R3_8 75 74 13
C3_81 75 84 5.3574e-17
C3_82 74 84 5.3574e-17
R3_9 72 74 78
C3_91 72 84 1.92866e-16
C3_92 74 84 1.92866e-16
R1_1 88 87 15
R1_2 90 89 15
R1_3 86 85 15
R1_4 84 86 26
C1_41 84 84 6.42888e-17
C1_42 86 84 6.42888e-17
R1_5 84 90 26
C1_51 84 84 6.42888e-17
C1_52 90 84 6.42888e-17
R1_6 84 88 26
C1_61 84 84 6.42888e-17
C1_62 88 84 6.42888e-17
.ends noa2a2a23_x1
