* Spice description of a4_x4
* Spice driver version -1098359891
* Date ( dd/mm/yyyy hh:mm:ss ):  8/05/2026 at 14:23:17

* INTERF i0 i1 i2 i3 q vdd vss

.subckt a4_x4 38 15 2 7 75 56 59
* NET 2 = i2
* NET 7 = i3
* NET 15 = i1
* NET 38 = i0
* NET 56 = vdd
* NET 59 = vss
* NET 75 = q
Mtr_00012 76 25 44 56 sky130_fd_pr__pfet_01v8__model L=0.15U W=2.46U AS=0.7134P AD=0.7134P PS=5.5U PD=5.5U
Mtr_00011 42 24 76 56 sky130_fd_pr__pfet_01v8__model L=0.15U W=2.46U AS=0.7134P AD=0.7134P PS=5.5U PD=5.5U
Mtr_00010 48 16 28 56 sky130_fd_pr__pfet_01v8__model L=0.15U W=1.26U AS=0.3654P AD=0.3654P PS=3.1U PD=3.1U
Mtr_00009 49 8 30 56 sky130_fd_pr__pfet_01v8__model L=0.15U W=1.26U AS=0.3654P AD=0.3654P PS=3.1U PD=3.1U
Mtr_00008 30 3 48 56 sky130_fd_pr__pfet_01v8__model L=0.15U W=1.26U AS=0.3654P AD=0.3654P PS=3.1U PD=3.1U
Mtr_00007 28 39 44 56 sky130_fd_pr__pfet_01v8__model L=0.15U W=1.26U AS=0.3654P AD=0.3654P PS=3.1U PD=3.1U
Mtr_00006 62 20 74 59 sky130_fd_pr__nfet_01v8__model L=0.15U W=1.26U AS=0.3654P AD=0.3654P PS=3.1U PD=3.1U
Mtr_00005 74 19 60 59 sky130_fd_pr__nfet_01v8__model L=0.15U W=1.26U AS=0.3654P AD=0.3654P PS=3.1U PD=3.1U
Mtr_00004 62 37 71 59 sky130_fd_pr__nfet_01v8__model L=0.15U W=1.26U AS=0.3654P AD=0.3654P PS=3.1U PD=3.1U
Mtr_00003 11 6 21 59 sky130_fd_pr__nfet_01v8__model L=0.15U W=1.26U AS=0.3654P AD=0.3654P PS=3.1U PD=3.1U
Mtr_00002 68 1 11 59 sky130_fd_pr__nfet_01v8__model L=0.15U W=1.26U AS=0.3654P AD=0.3654P PS=3.1U PD=3.1U
Mtr_00001 71 14 68 59 sky130_fd_pr__nfet_01v8__model L=0.15U W=1.26U AS=0.3654P AD=0.3654P PS=3.1U PD=3.1U
R11_1 1 2 15
R11_2 3 2 15
R10_1 6 7 15
R10_2 8 7 15
R8_1 14 15 15
R8_2 16 15 15
R7_1 26 27 15
R7_2 22 21 15
R7_3 23 21 15
R7_4 31 30 15
R7_5 29 28 15
R7_6 34 30 15
R7_7 33 28 15
R7_8 29 33 13
C7_81 29 59 5.3574e-17
C7_82 33 59 5.3574e-17
R7_9 31 34 13
C7_91 31 59 5.3574e-17
C7_92 34 59 5.3574e-17
R7_10 31 32 26
C7_101 31 59 6.42888e-17
C7_102 32 59 6.42888e-17
R7_11 29 31 52
C7_111 29 59 1.28578e-16
C7_112 31 59 1.28578e-16
R7_12 27 32 78
C7_121 27 59 1.82152e-16
C7_122 32 59 1.82152e-16
R7_13 23 27 39
C7_131 23 59 9.64332e-17
C7_132 27 59 9.64332e-17
R7_14 22 23 26
C7_141 22 59 7.50036e-17
C7_142 23 59 7.50036e-17
R7_15 26 25 480
C7_151 26 59 8.69778e-17
C7_152 25 59 8.69778e-17
R7_16 20 26 480
C7_161 20 59 8.0535e-17
C7_162 26 59 8.0535e-17
R7_17 26 24 480
C7_171 26 59 8.69778e-17
C7_172 24 59 8.69778e-17
R7_18 19 26 480
C7_181 19 59 8.0535e-17
C7_182 26 59 8.0535e-17
R6_1 37 38 15
R6_2 39 38 15
R5_1 53 44 15
R5_2 51 44 15
R5_3 47 44 15
R5_4 44 45 15
R5_5 54 48 15
R5_6 55 49 15
R5_7 50 42 15
R5_8 46 42 15
R5_9 52 42 15
R5_10 43 42 15
R5_11 52 56 26
C5_111 52 59 6.42888e-17
C5_112 56 59 6.42888e-17
R5_12 50 52 13
C5_121 50 59 5.3574e-17
C5_122 52 59 5.3574e-17
R5_13 46 50 26
C5_131 46 59 6.42888e-17
C5_132 50 59 6.42888e-17
R5_14 43 46 26
C5_141 43 59 6.42888e-17
C5_142 46 59 6.42888e-17
R5_15 55 56 26
C5_151 55 59 6.42888e-17
C5_152 56 59 6.42888e-17
R5_16 54 56 26
C5_161 54 59 6.42888e-17
C5_162 56 59 6.42888e-17
R5_17 53 56 26
C5_171 53 59 6.42888e-17
C5_172 56 59 6.42888e-17
R5_18 51 53 13
C5_181 51 59 5.3574e-17
C5_182 53 59 5.3574e-17
R5_19 47 51 26
C5_191 47 59 6.42888e-17
C5_192 51 59 6.42888e-17
R5_20 45 47 26
C5_201 45 59 6.42888e-17
C5_202 47 59 6.42888e-17
R4_1 63 62 15
R4_2 65 62 15
R4_3 64 60 15
R4_4 61 60 15
R4_5 61 64 26
C4_51 61 59 7.50036e-17
C4_52 64 59 7.50036e-17
R4_6 59 61 26
C4_61 59 59 6.42888e-17
C4_62 61 59 6.42888e-17
R4_7 63 65 26
C4_71 63 59 7.50036e-17
C4_72 65 59 7.50036e-17
R4_8 59 63 26
C4_81 59 59 6.42888e-17
C4_82 63 59 6.42888e-17
R1_1 75 74 7.5
R1_2 75 76 3.75
.ends a4_x4
