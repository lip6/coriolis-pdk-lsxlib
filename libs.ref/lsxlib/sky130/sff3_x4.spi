* Spice description of sff3_x4
* Spice driver version -1551889491
* Date ( dd/mm/yyyy hh:mm:ss ):  8/05/2026 at 14:22:51

* INTERF ck cmd0 cmd1 i0 i1 i2 q vdd vss

.subckt sff3_x4 121 127 198 136 185 192 27 228 271
* NET 27 = q
* NET 36 = y
* NET 52 = sff_s
* NET 71 = ckr
* NET 97 = sff_m
* NET 121 = ck
* NET 127 = cmd0
* NET 136 = i0
* NET 185 = i1
* NET 192 = i2
* NET 198 = cmd1
* NET 228 = vdd
* NET 251 = u
* NET 271 = vss
Mtr_00042 46 110 217 228 sky130_fd_pr__pfet_01v8__model L=0.15U W=1.02U AS=0.2958P AD=0.2958P PS=2.62U PD=2.62U
Mtr_00041 62 92 1 228 sky130_fd_pr__pfet_01v8__model L=0.15U W=1.26U AS=0.3654P AD=0.3654P PS=3.1U PD=3.1U
Mtr_00040 22 244 260 228 sky130_fd_pr__pfet_01v8__model L=0.15U W=1.14U AS=0.3306P AD=0.3306P PS=2.86U PD=2.86U
Mtr_00039 263 138 10 228 sky130_fd_pr__pfet_01v8__model L=0.15U W=1.14U AS=0.3306P AD=0.3306P PS=2.86U PD=2.86U
Mtr_00038 19 194 13 228 sky130_fd_pr__pfet_01v8__model L=0.15U W=1.14U AS=0.3306P AD=0.3306P PS=2.86U PD=2.86U
Mtr_00037 14 188 22 228 sky130_fd_pr__pfet_01v8__model L=0.15U W=1.14U AS=0.3306P AD=0.3306P PS=2.86U PD=2.86U
Mtr_00036 209 131 176 228 sky130_fd_pr__pfet_01v8__model L=0.15U W=0.78U AS=0.2262P AD=0.2262P PS=2.14U PD=2.14U
Mtr_00035 46 166 62 228 sky130_fd_pr__pfet_01v8__model L=0.15U W=1.02U AS=0.2958P AD=0.2958P PS=2.62U PD=2.62U
Mtr_00034 7 44 217 228 sky130_fd_pr__pfet_01v8__model L=0.15U W=1.02U AS=0.2958P AD=0.2958P PS=2.62U PD=2.62U
Mtr_00033 108 164 7 228 sky130_fd_pr__pfet_01v8__model L=0.15U W=1.02U AS=0.2958P AD=0.2958P PS=2.62U PD=2.62U
Mtr_00032 210 60 32 228 sky130_fd_pr__pfet_01v8__model L=0.15U W=2.46U AS=0.7134P AD=0.7134P PS=5.5U PD=5.5U
Mtr_00031 32 61 211 228 sky130_fd_pr__pfet_01v8__model L=0.15U W=2.46U AS=0.7134P AD=0.7134P PS=5.5U PD=5.5U
Mtr_00030 260 204 19 228 sky130_fd_pr__pfet_01v8__model L=0.15U W=1.14U AS=0.3306P AD=0.3306P PS=2.86U PD=2.86U
Mtr_00029 216 266 4 228 sky130_fd_pr__pfet_01v8__model L=0.15U W=1.02U AS=0.2958P AD=0.2958P PS=2.62U PD=2.62U
Mtr_00028 4 90 108 228 sky130_fd_pr__pfet_01v8__model L=0.15U W=1.02U AS=0.2958P AD=0.2958P PS=2.62U PD=2.62U
Mtr_00027 215 178 14 228 sky130_fd_pr__pfet_01v8__model L=0.15U W=1.14U AS=0.3306P AD=0.3306P PS=2.86U PD=2.86U
Mtr_00026 10 132 215 228 sky130_fd_pr__pfet_01v8__model L=0.15U W=1.14U AS=0.3306P AD=0.3306P PS=2.86U PD=2.86U
Mtr_00025 209 123 159 228 sky130_fd_pr__pfet_01v8__model L=0.15U W=1.02U AS=0.2958P AD=0.2958P PS=2.62U PD=2.62U
Mtr_00024 87 163 216 228 sky130_fd_pr__pfet_01v8__model L=0.15U W=1.02U AS=0.2958P AD=0.2958P PS=2.62U PD=2.62U
Mtr_00023 241 200 208 228 sky130_fd_pr__pfet_01v8__model L=0.15U W=0.78U AS=0.2262P AD=0.2262P PS=2.14U PD=2.14U
Mtr_00022 1 33 210 228 sky130_fd_pr__pfet_01v8__model L=0.15U W=1.26U AS=0.3654P AD=0.3654P PS=3.1U PD=3.1U
Mtr_00021 68 147 52 271 sky130_fd_pr__nfet_01v8__model L=0.15U W=0.66U AS=0.1914P AD=0.1914P PS=1.9U PD=1.9U
Mtr_00020 117 258 275 271 sky130_fd_pr__nfet_01v8__model L=0.15U W=0.54U AS=0.1566P AD=0.1566P PS=1.66U PD=1.66U
Mtr_00019 97 145 117 271 sky130_fd_pr__nfet_01v8__model L=0.15U W=0.54U AS=0.1566P AD=0.1566P PS=1.66U PD=1.66U
Mtr_00018 276 36 114 271 sky130_fd_pr__nfet_01v8__model L=0.15U W=0.54U AS=0.1566P AD=0.1566P PS=1.66U PD=1.66U
Mtr_00017 233 186 289 271 sky130_fd_pr__nfet_01v8__model L=0.15U W=0.54U AS=0.1566P AD=0.1566P PS=1.66U PD=1.66U
Mtr_00016 248 191 231 271 sky130_fd_pr__nfet_01v8__model L=0.15U W=0.54U AS=0.1566P AD=0.1566P PS=1.66U PD=1.66U
Mtr_00015 275 144 71 271 sky130_fd_pr__nfet_01v8__model L=0.15U W=0.54U AS=0.1566P AD=0.1566P PS=1.66U PD=1.66U
Mtr_00014 182 170 273 271 sky130_fd_pr__nfet_01v8__model L=0.15U W=0.54U AS=0.1566P AD=0.1566P PS=1.66U PD=1.66U
Mtr_00013 272 197 237 271 sky130_fd_pr__nfet_01v8__model L=0.15U W=0.42U AS=0.1218P AD=0.1218P PS=1.42U PD=1.42U
Mtr_00012 39 99 276 271 sky130_fd_pr__nfet_01v8__model L=0.15U W=0.54U AS=0.1566P AD=0.1566P PS=1.66U PD=1.66U
Mtr_00011 52 74 39 271 sky130_fd_pr__nfet_01v8__model L=0.15U W=0.54U AS=0.1566P AD=0.1566P PS=1.66U PD=1.66U
Mtr_00010 289 199 251 271 sky130_fd_pr__nfet_01v8__model L=0.15U W=0.54U AS=0.1566P AD=0.1566P PS=1.66U PD=1.66U
Mtr_00009 114 73 97 271 sky130_fd_pr__nfet_01v8__model L=0.15U W=0.54U AS=0.1566P AD=0.1566P PS=1.66U PD=1.66U
Mtr_00008 173 128 274 271 sky130_fd_pr__nfet_01v8__model L=0.15U W=0.42U AS=0.1218P AD=0.1218P PS=1.42U PD=1.42U
Mtr_00007 254 135 182 271 sky130_fd_pr__nfet_01v8__model L=0.15U W=0.54U AS=0.1566P AD=0.1566P PS=1.66U PD=1.66U
Mtr_00006 273 126 233 271 sky130_fd_pr__nfet_01v8__model L=0.15U W=0.54U AS=0.1566P AD=0.1566P PS=1.66U PD=1.66U
Mtr_00005 274 120 141 271 sky130_fd_pr__nfet_01v8__model L=0.15U W=0.54U AS=0.1566P AD=0.1566P PS=1.66U PD=1.66U
Mtr_00004 251 239 248 271 sky130_fd_pr__nfet_01v8__model L=0.15U W=0.54U AS=0.1566P AD=0.1566P PS=1.66U PD=1.66U
Mtr_00003 277 25 68 271 sky130_fd_pr__nfet_01v8__model L=0.15U W=0.66U AS=0.1914P AD=0.1914P PS=1.9U PD=1.9U
Mtr_00002 278 56 26 271 sky130_fd_pr__nfet_01v8__model L=0.15U W=1.26U AS=0.3654P AD=0.3654P PS=3.1U PD=3.1U
Mtr_00001 26 55 277 271 sky130_fd_pr__nfet_01v8__model L=0.15U W=1.26U AS=0.3654P AD=0.3654P PS=3.1U PD=3.1U
R27_1 15 13 15
R27_2 16 14 15
R27_3 15 16 104
C27_31 15 271 2.4644e-16
C27_32 16 271 2.4644e-16
R24_1 29 28 15
R24_2 27 32 3.75
R24_3 27 26 7.5
R24_4 31 30 15
R24_5 31 33 576
C24_51 31 271 9.98634e-17
C24_52 33 271 9.98634e-17
R24_6 30 27 39
C24_61 30 271 9.64332e-17
C24_62 27 271 9.64332e-17
R24_7 28 27 39
C24_71 28 271 9.64332e-17
C24_72 27 271 9.64332e-17
R24_8 25 29 288
C24_81 25 271 5.15424e-17
C24_82 29 271 5.15424e-17
R23_1 40 39 15
R23_2 36 37 15
R23_3 49 46 15
R23_4 47 46 15
R23_5 44 45 15
R23_6 45 48 39
C23_61 45 271 9.64332e-17
C23_62 48 271 9.64332e-17
R23_7 47 49 13
C23_71 47 271 4.28592e-17
C23_72 49 271 4.28592e-17
R23_8 48 47 13
C23_81 48 271 5.3574e-17
C23_82 47 271 5.3574e-17
R23_9 43 48 52
C23_91 43 271 1.17863e-16
C23_92 48 271 1.17863e-16
R23_10 42 43 13
C23_101 42 271 4.28592e-17
C23_102 43 271 4.28592e-17
R23_11 38 42 52
C23_111 38 271 1.39292e-16
C23_112 42 271 1.39292e-16
R23_12 38 41 13
C23_121 38 271 4.28592e-17
C23_122 41 271 4.28592e-17
R23_13 37 38 13
C23_131 37 271 5.3574e-17
C23_132 38 271 5.3574e-17
R23_14 40 41 13
C23_141 40 271 5.3574e-17
C23_142 41 271 5.3574e-17
R22_1 53 52 15
R22_2 63 62 15
R22_3 59 58 15
R22_4 64 62 15
R22_5 59 61 576
C22_51 59 271 9.98634e-17
C22_52 61 271 9.98634e-17
R22_6 56 59 384
C22_61 56 271 6.76494e-17
C22_62 59 271 6.76494e-17
R22_7 59 60 576
C22_71 59 271 9.98634e-17
C22_72 60 271 9.98634e-17
R22_8 55 59 384
C22_81 55 271 6.76494e-17
C22_82 59 271 6.76494e-17
R22_9 63 64 13
C22_91 63 271 4.28592e-17
C22_92 64 271 4.28592e-17
R22_10 57 58 39
C22_101 57 271 9.64332e-17
C22_102 58 271 9.64332e-17
R22_11 63 65 13
C22_111 63 271 4.28592e-17
C22_112 65 271 4.28592e-17
R22_12 57 65 91
C22_121 57 271 2.14296e-16
C22_122 65 271 2.14296e-16
R22_13 54 57 65
C22_131 54 271 1.50007e-16
C22_132 57 271 1.50007e-16
R22_14 53 54 13
C22_141 53 271 4.28592e-17
C22_142 54 271 4.28592e-17
R20_1 72 71 15
R20_2 78 77 15
R20_3 89 87 15
R20_4 83 82 15
R20_5 81 80 15
R20_6 90 91 15
R20_7 94 93 7.5
R20_8 94 92 384
C20_81 94 271 6.76494e-17
C20_82 92 271 6.76494e-17
R20_9 80 93 65
C20_91 80 271 1.50007e-16
C20_92 93 271 1.50007e-16
R20_10 85 91 52
C20_101 85 271 1.17863e-16
C20_102 91 271 1.17863e-16
R20_11 85 86 26
C20_111 85 271 6.42888e-17
C20_112 86 271 6.42888e-17
R20_12 81 84 144
C20_121 81 271 2.57712e-17
C20_122 84 271 2.57712e-17
R20_13 74 81 336
C20_131 74 271 6.12066e-17
C20_132 81 271 6.12066e-17
R20_14 82 86 13
C20_141 82 271 3.21444e-17
C20_142 86 271 3.21444e-17
R20_15 83 84 624
C20_151 83 271 1.09528e-16
C20_152 84 271 1.09528e-16
R20_16 79 83 192
C20_161 79 271 3.78515e-17
C20_162 83 271 3.78515e-17
R20_17 73 79 288
C20_171 73 271 5.47638e-17
C20_172 79 271 5.47638e-17
R20_18 78 79 576
C20_181 78 271 1.03085e-16
C20_182 79 271 1.03085e-16
R20_19 89 88 13
C20_191 89 271 4.28592e-17
C20_192 88 271 4.28592e-17
R20_20 77 88 78
C20_201 77 271 2.03581e-16
C20_202 88 271 2.03581e-16
R20_21 76 77 13
C20_211 76 271 4.28592e-17
C20_212 77 271 4.28592e-17
R20_22 75 76 13
C20_221 75 271 4.28592e-17
C20_222 76 271 4.28592e-17
R20_23 72 75 13
C20_231 72 271 5.3574e-17
C20_232 75 271 5.3574e-17
R19_1 98 97 15
R19_2 102 101 15
R19_3 106 105 15
R19_4 109 108 15
R19_5 111 108 15
R19_6 109 111 13
C19_61 109 271 4.28592e-17
C19_62 111 271 4.28592e-17
R19_7 107 110 432
C19_71 107 271 7.40922e-17
C19_72 110 271 7.40922e-17
R19_8 104 109 39
C19_81 104 271 1.07148e-16
C19_82 109 271 1.07148e-16
R19_9 106 107 192
C19_91 106 271 3.86568e-17
C19_92 107 271 3.86568e-17
R19_10 99 103 336
C19_101 99 271 6.12066e-17
C19_102 103 271 6.12066e-17
R19_11 104 105 26
C19_111 104 271 6.42888e-17
C19_112 105 271 6.42888e-17
R19_12 102 103 192
C19_121 102 271 3.86568e-17
C19_122 103 271 3.86568e-17
R19_13 101 105 65
C19_131 101 271 1.50007e-16
C19_132 105 271 1.50007e-16
R19_14 100 101 26
C19_141 100 271 6.42888e-17
C19_142 101 271 6.42888e-17
R19_15 98 100 39
C19_151 98 271 1.07148e-16
C19_152 100 271 1.07148e-16
R16_1 122 121 15
R16_2 122 123 672
C16_21 122 271 1.19192e-16
C16_22 123 271 1.19192e-16
R16_3 120 122 624
C16_31 120 271 1.06306e-16
C16_32 122 271 1.06306e-16
R15_1 129 127 15
R15_2 128 131 576
C15_21 128 271 1.0389e-16
C15_22 131 271 1.0389e-16
R15_3 129 132 576
C15_31 129 271 1.03085e-16
C15_32 132 271 1.03085e-16
R15_4 129 131 480
C15_41 129 271 8.29511e-17
C15_42 131 271 8.29511e-17
R15_5 130 129 192
C15_51 130 271 3.30194e-17
C15_52 129 271 3.30194e-17
R15_6 126 130 672
C15_61 126 271 1.19192e-16
C15_62 130 271 1.19192e-16
R14_1 137 136 15
R14_2 138 136 15
R14_3 135 137 528
C14_31 135 271 9.34206e-17
C14_32 137 271 9.34206e-17
R13_1 142 141 15
R13_2 153 152 15
R13_3 162 159 15
R13_4 151 150 15
R13_5 145 146 15
R13_6 146 150 26
C13_61 146 271 8.57184e-17
C13_62 150 271 8.57184e-17
R13_7 165 166 48
C13_71 165 271 1.28856e-17
C13_72 166 271 1.28856e-17
R13_8 143 144 96
C13_81 143 271 1.93284e-17
C13_82 144 271 1.93284e-17
R13_9 154 163 624
C13_91 154 271 1.06306e-16
C13_92 163 271 1.06306e-16
R13_10 156 164 624
C13_101 156 271 1.06306e-16
C13_102 164 271 1.06306e-16
R13_11 151 155 96
C13_111 151 271 4.02898e-17
C13_112 155 271 4.02898e-17
R13_12 157 165 384
C13_121 157 271 7.08708e-17
C13_122 165 271 7.08708e-17
R13_13 147 158 672
C13_131 147 271 1.1597e-16
C13_132 158 271 1.1597e-16
R13_14 143 153 576
C13_141 143 271 9.6642e-17
C13_142 153 271 9.6642e-17
R13_15 157 158 288
C13_151 157 271 5.15424e-17
C13_152 158 271 5.15424e-17
R13_16 156 157 576
C13_161 156 271 9.6642e-17
C13_162 157 271 9.6642e-17
R13_17 155 156 192
C13_171 155 271 3.86568e-17
C13_172 156 271 3.86568e-17
R13_18 154 155 384
C13_181 154 271 7.08708e-17
C13_182 155 271 7.08708e-17
R13_19 153 154 144
C13_191 153 271 2.49659e-17
C13_192 154 271 2.49659e-17
R13_20 161 162 13
C13_201 161 271 5.3574e-17
C13_202 162 271 5.3574e-17
R13_21 161 160 13
C13_211 161 271 5.3574e-17
C13_212 160 271 5.3574e-17
R13_22 152 160 13
C13_221 152 271 4.28592e-17
C13_222 160 271 4.28592e-17
R13_23 149 152 39
C13_231 149 271 9.64332e-17
C13_232 152 271 9.64332e-17
R13_24 148 149 13
C13_241 148 271 5.3574e-17
C13_242 149 271 5.3574e-17
R13_25 142 148 39
C13_251 142 271 1.07148e-16
C13_252 148 271 1.07148e-16
R12_1 175 173 15
R12_2 177 176 15
R12_3 170 171 15
R12_4 178 179 15
R12_5 169 179 104
C12_51 169 271 2.4644e-16
C12_52 179 271 2.4644e-16
R12_6 171 172 13
C12_61 171 271 4.28592e-17
C12_62 172 271 4.28592e-17
R12_7 169 171 26
C12_71 169 271 6.42888e-17
C12_72 171 271 6.42888e-17
R12_8 172 174 13
C12_81 172 271 5.3574e-17
C12_82 174 271 5.3574e-17
R12_9 174 175 13
C12_91 174 271 5.3574e-17
C12_92 175 271 5.3574e-17
R12_10 175 177 52
C12_101 175 271 1.39292e-16
C12_102 177 271 1.39292e-16
R10_1 187 185 15
R10_2 187 188 768
C10_21 187 271 1.28856e-16
C10_22 188 271 1.28856e-16
R10_3 186 187 528
C10_31 186 271 9.34206e-17
C10_32 187 271 9.34206e-17
R9_1 193 192 15
R9_2 193 194 768
C9_21 193 271 1.28856e-16
C9_22 194 271 1.28856e-16
R9_3 191 193 528
C9_31 191 271 9.34206e-17
C9_32 193 271 9.34206e-17
R8_1 201 198 15
R8_2 204 205 15
R8_3 199 203 384
C8_31 199 271 6.76494e-17
C8_32 203 271 6.76494e-17
R8_4 202 203 192
C8_41 202 271 3.2214e-17
C8_42 203 271 3.2214e-17
R8_5 202 204 864
C8_51 202 271 1.46574e-16
C8_52 204 271 1.46574e-16
R8_6 198 205 52
C8_61 198 271 1.39292e-16
C8_62 205 271 1.39292e-16
R8_7 201 200 288
C8_71 201 271 4.8321e-17
C8_72 200 271 4.8321e-17
R8_8 197 201 288
C8_81 197 271 5.15424e-17
C8_82 201 271 5.15424e-17
R7_1 223 208 15
R7_2 222 211 15
R7_3 214 211 15
R7_4 212 211 15
R7_5 219 211 15
R7_6 227 217 15
R7_7 220 217 15
R7_8 221 210 15
R7_9 218 210 15
R7_10 213 210 15
R7_11 226 216 15
R7_12 224 215 15
R7_13 225 209 15
R7_14 225 228 26
C7_141 225 271 6.42888e-17
C7_142 228 271 6.42888e-17
R7_15 224 228 26
C7_151 224 271 6.42888e-17
C7_152 228 271 6.42888e-17
R7_16 226 228 26
C7_161 226 271 6.42888e-17
C7_162 228 271 6.42888e-17
R7_17 221 228 26
C7_171 221 271 7.50036e-17
C7_172 228 271 7.50036e-17
R7_18 218 221 13
C7_181 218 271 5.3574e-17
C7_182 221 271 5.3574e-17
R7_19 213 218 13
C7_191 213 271 5.3574e-17
C7_192 218 271 5.3574e-17
R7_20 227 228 26
C7_201 227 271 6.42888e-17
C7_202 228 271 6.42888e-17
R7_21 220 227 13
C7_211 220 271 4.28592e-17
C7_212 227 271 4.28592e-17
R7_22 222 228 26
C7_221 222 271 7.50036e-17
C7_222 228 271 7.50036e-17
R7_23 219 222 13
C7_231 219 271 5.3574e-17
C7_232 222 271 5.3574e-17
R7_24 214 219 13
C7_241 214 271 5.3574e-17
C7_242 219 271 5.3574e-17
R7_25 212 214 13
C7_251 212 271 5.3574e-17
C7_252 214 271 5.3574e-17
R7_26 223 228 26
C7_261 223 271 6.42888e-17
C7_262 228 271 6.42888e-17
R6_1 232 231 15
R6_2 234 233 15
R6_3 232 234 104
C6_31 232 271 2.4644e-16
C6_32 234 271 2.4644e-16
R5_1 238 237 15
R5_2 242 241 15
R5_3 239 240 15
R5_4 244 245 15
R5_5 243 245 13
C5_51 243 271 5.3574e-17
C5_52 245 271 5.3574e-17
R5_6 242 243 65
C5_61 242 271 1.50007e-16
C5_62 243 271 1.50007e-16
R5_7 238 240 26
C5_71 238 271 7.50036e-17
C5_72 240 271 7.50036e-17
R5_8 238 242 65
C5_81 238 271 1.71437e-16
C5_82 242 271 1.71437e-16
R3_1 252 251 15
R3_2 264 263 15
R3_3 261 260 15
R3_4 266 268 15
R3_5 258 259 15
R3_6 255 254 15
R3_7 255 257 13
C3_71 255 271 5.3574e-17
C3_72 257 271 5.3574e-17
R3_8 257 256 13
C3_81 257 271 5.3574e-17
C3_82 256 271 5.3574e-17
R3_9 256 265 130
C3_91 256 271 3.00014e-16
C3_92 265 271 3.00014e-16
R3_10 268 267 13
C3_101 268 271 4.28592e-17
C3_102 267 271 4.28592e-17
R3_11 259 268 104
C3_111 259 271 2.57155e-16
C3_112 268 271 2.57155e-16
R3_12 265 267 104
C3_121 265 271 2.35726e-16
C3_122 267 271 2.35726e-16
R3_13 264 265 26
C3_131 264 271 6.42888e-17
C3_132 265 271 6.42888e-17
R3_14 262 264 91
C3_141 262 271 2.25011e-16
C3_142 264 271 2.25011e-16
R3_15 261 262 26
C3_151 261 271 7.50036e-17
C3_152 262 271 7.50036e-17
R3_16 253 262 130
C3_161 253 271 3.00014e-16
C3_162 262 271 3.00014e-16
R3_17 252 253 26
C3_171 252 271 7.50036e-17
C3_172 253 271 7.50036e-17
R2_1 279 272 15
R2_2 284 278 15
R2_3 286 278 15
R2_4 285 277 15
R2_5 283 276 15
R2_6 282 275 15
R2_7 281 274 15
R2_8 280 273 15
R2_9 271 280 26
C2_91 271 271 6.42888e-17
C2_92 280 271 6.42888e-17
R2_10 271 281 26
C2_101 271 271 6.42888e-17
C2_102 281 271 6.42888e-17
R2_11 271 282 26
C2_111 271 271 6.42888e-17
C2_112 282 271 6.42888e-17
R2_12 271 283 26
C2_121 271 271 6.42888e-17
C2_122 283 271 6.42888e-17
R2_13 271 285 26
C2_131 271 271 8.57184e-17
C2_132 285 271 8.57184e-17
R2_14 284 286 26
C2_141 284 271 6.42888e-17
C2_142 286 271 6.42888e-17
R2_15 271 284 26
C2_151 271 271 6.42888e-17
C2_152 284 271 6.42888e-17
R2_16 271 279 26
C2_161 271 271 6.42888e-17
C2_162 279 271 6.42888e-17
.ends sff3_x4
