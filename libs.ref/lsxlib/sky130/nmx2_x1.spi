* Spice description of nmx2_x1
* Spice driver version -1017001043
* Date ( dd/mm/yyyy hh:mm:ss ):  8/05/2026 at 14:22:51

* INTERF cmd i0 i1 nq vdd vss

.subckt nmx2_x1 12 20 2 49 32 38
* NET 2 = i1
* NET 12 = cmd
* NET 20 = i0
* NET 32 = vdd
* NET 38 = vss
* NET 49 = nq
Mtr_00010 66 16 28 32 sky130_fd_pr__pfet_01v8__model L=0.15U W=1.14U AS=0.3306P AD=0.3306P PS=2.86U PD=2.86U
Mtr_00009 50 64 35 32 sky130_fd_pr__pfet_01v8__model L=0.15U W=2.22U AS=0.6438P AD=0.6438P PS=5.02U PD=5.02U
Mtr_00008 25 17 50 32 sky130_fd_pr__pfet_01v8__model L=0.15U W=2.22U AS=0.6438P AD=0.6438P PS=5.02U PD=5.02U
Mtr_00007 35 4 29 32 sky130_fd_pr__pfet_01v8__model L=0.15U W=2.22U AS=0.6438P AD=0.6438P PS=5.02U PD=5.02U
Mtr_00006 28 22 25 32 sky130_fd_pr__pfet_01v8__model L=0.15U W=2.22U AS=0.6438P AD=0.6438P PS=5.02U PD=5.02U
Mtr_00005 39 9 56 38 sky130_fd_pr__nfet_01v8__model L=0.15U W=0.54U AS=0.1566P AD=0.1566P PS=1.66U PD=1.66U
Mtr_00004 53 10 48 38 sky130_fd_pr__nfet_01v8__model L=0.15U W=1.14U AS=0.3306P AD=0.3306P PS=2.86U PD=2.86U
Mtr_00003 48 59 45 38 sky130_fd_pr__nfet_01v8__model L=0.15U W=1.14U AS=0.3306P AD=0.3306P PS=2.86U PD=2.86U
Mtr_00002 41 1 53 38 sky130_fd_pr__nfet_01v8__model L=0.15U W=1.14U AS=0.3306P AD=0.3306P PS=2.86U PD=2.86U
Mtr_00001 45 21 39 38 sky130_fd_pr__nfet_01v8__model L=0.15U W=1.14U AS=0.3306P AD=0.3306P PS=2.86U PD=2.86U
R11_1 5 2 15
R11_2 1 3 96
C11_21 1 38 1.93284e-17
C11_22 3 38 1.93284e-17
R11_3 5 6 192
C11_31 5 38 3.2214e-17
C11_32 6 38 3.2214e-17
R11_4 3 5 192
C11_41 3 38 3.86568e-17
C11_42 5 38 3.86568e-17
R11_5 4 6 96
C11_51 4 38 1.93284e-17
C11_52 6 38 1.93284e-17
R10_1 13 12 15
R10_2 14 10 48
C10_21 14 38 1.28856e-17
C10_22 10 38 1.28856e-17
R10_3 11 16 768
C10_31 11 38 1.28856e-16
C10_32 16 38 1.28856e-16
R10_4 9 11 528
C10_41 9 38 9.34206e-17
C10_42 11 38 9.34206e-17
R10_5 14 15 192
C10_51 14 38 3.86568e-17
C10_52 15 38 3.86568e-17
R10_6 13 17 576
C10_61 13 38 9.98634e-17
C10_62 17 38 9.98634e-17
R10_7 13 15 192
C10_71 13 38 3.46301e-17
C10_72 15 38 3.46301e-17
R10_8 11 13 336
C10_81 11 38 6.2012e-17
C10_82 13 38 6.2012e-17
R9_1 22 20 15
R9_2 21 20 15
R7_1 30 28 15
R7_2 31 29 15
R7_3 31 32 26
C7_31 31 38 6.42888e-17
C7_32 32 38 6.42888e-17
R7_4 30 32 26
C7_41 30 38 6.42888e-17
C7_42 32 38 6.42888e-17
R5_1 40 39 15
R5_2 42 41 15
R5_3 38 42 26
C5_31 38 38 6.42888e-17
C5_32 42 38 6.42888e-17
R5_4 38 40 26
C5_41 38 38 6.42888e-17
C5_42 40 38 6.42888e-17
R3_1 49 48 7.5
R3_2 49 50 5
R1_1 57 56 15
R1_2 67 66 15
R1_3 69 66 15
R1_4 59 61 15
R1_5 63 62 15
R1_6 64 65 48
C1_61 64 38 1.28856e-17
C1_62 65 38 1.28856e-17
R1_7 62 65 192
C1_71 62 38 3.2214e-17
C1_72 65 38 3.2214e-17
R1_8 63 71 104
C1_81 63 38 2.4644e-16
C1_82 71 38 2.4644e-16
R1_9 70 71 52
C1_91 70 38 1.28578e-16
C1_92 71 38 1.28578e-16
R1_10 60 61 13
C1_101 60 38 5.3574e-17
C1_102 61 38 5.3574e-17
R1_11 68 70 13
C1_111 68 38 5.3574e-17
C1_112 70 38 5.3574e-17
R1_12 58 60 52
C1_121 58 38 1.28578e-16
C1_122 60 38 1.28578e-16
R1_13 67 68 52
C1_131 67 38 1.28578e-16
C1_132 68 38 1.28578e-16
R1_14 67 69 26
C1_141 67 38 5.89314e-17
C1_142 69 38 5.89314e-17
R1_15 58 67 130
C1_151 58 38 2.94657e-16
C1_152 67 38 2.94657e-16
R1_16 57 58 13
C1_161 57 38 5.3574e-17
C1_162 58 38 5.3574e-17
.ends nmx2_x1
