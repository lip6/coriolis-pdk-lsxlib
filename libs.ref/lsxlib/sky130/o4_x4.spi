* Spice description of o4_x4
* Spice driver version -1319527507
* Date ( dd/mm/yyyy hh:mm:ss ):  8/05/2026 at 14:22:51

* INTERF i0 i1 i2 i3 q vdd vss

.subckt o4_x4 8 25 13 19 2 43 72
* NET 2 = q
* NET 8 = i0
* NET 13 = i2
* NET 19 = i3
* NET 25 = i1
* NET 43 = vdd
* NET 72 = vss
Mtr_00012 3 64 35 43 sky130_fd_pr__pfet_01v8__model L=0.15U W=2.46U AS=0.7134P AD=0.7134P PS=5.5U PD=5.5U
Mtr_00011 49 14 46 43 sky130_fd_pr__pfet_01v8__model L=0.15U W=2.46U AS=0.7134P AD=0.7134P PS=5.5U PD=5.5U
Mtr_00010 65 20 49 43 sky130_fd_pr__pfet_01v8__model L=0.15U W=2.46U AS=0.7134P AD=0.7134P PS=5.5U PD=5.5U
Mtr_00009 30 26 46 43 sky130_fd_pr__pfet_01v8__model L=0.15U W=2.46U AS=0.7134P AD=0.7134P PS=5.5U PD=5.5U
Mtr_00008 33 6 30 43 sky130_fd_pr__pfet_01v8__model L=0.15U W=2.46U AS=0.7134P AD=0.7134P PS=5.5U PD=5.5U
Mtr_00007 3 63 33 43 sky130_fd_pr__pfet_01v8__model L=0.15U W=2.46U AS=0.7134P AD=0.7134P PS=5.5U PD=5.5U
Mtr_00006 79 60 1 72 sky130_fd_pr__nfet_01v8__model L=0.15U W=1.26U AS=0.3654P AD=0.3654P PS=3.1U PD=3.1U
Mtr_00005 75 12 52 72 sky130_fd_pr__nfet_01v8__model L=0.15U W=0.66U AS=0.1914P AD=0.1914P PS=1.9U PD=1.9U
Mtr_00004 52 18 73 72 sky130_fd_pr__nfet_01v8__model L=0.15U W=0.66U AS=0.1914P AD=0.1914P PS=1.9U PD=1.9U
Mtr_00003 56 7 77 72 sky130_fd_pr__nfet_01v8__model L=0.15U W=0.66U AS=0.1914P AD=0.1914P PS=1.9U PD=1.9U
Mtr_00002 75 24 56 72 sky130_fd_pr__nfet_01v8__model L=0.15U W=0.66U AS=0.1914P AD=0.1914P PS=1.9U PD=1.9U
Mtr_00001 1 60 77 72 sky130_fd_pr__nfet_01v8__model L=0.15U W=1.26U AS=0.3654P AD=0.3654P PS=3.1U PD=3.1U
R11_1 2 1 7.5
R11_2 2 3 3.75
R10_1 9 8 15
R10_2 9 6 480
C10_21 9 72 8.69778e-17
C10_22 6 72 8.69778e-17
R10_3 7 9 576
C10_31 7 72 9.6642e-17
C10_32 9 72 9.6642e-17
R9_1 15 13 15
R9_2 15 14 480
C9_21 15 72 8.69778e-17
C9_22 14 72 8.69778e-17
R9_3 12 15 576
C9_31 12 72 9.6642e-17
C9_32 15 72 9.6642e-17
R8_1 21 19 15
R8_2 21 20 480
C8_21 21 72 8.69778e-17
C8_22 20 72 8.69778e-17
R8_3 18 21 576
C8_31 18 72 9.6642e-17
C8_32 21 72 9.6642e-17
R7_1 27 25 15
R7_2 27 26 480
C7_21 27 72 8.69778e-17
C7_22 26 72 8.69778e-17
R7_3 24 27 576
C7_31 24 72 9.6642e-17
C7_32 27 72 9.6642e-17
R5_1 41 33 15
R5_2 37 33 15
R5_3 39 33 15
R5_4 33 34 15
R5_5 38 35 15
R5_6 40 35 15
R5_7 42 35 15
R5_8 36 35 15
R5_9 42 43 26
C5_91 42 72 6.42888e-17
C5_92 43 72 6.42888e-17
R5_10 40 42 13
C5_101 40 72 5.3574e-17
C5_102 42 72 5.3574e-17
R5_11 38 40 26
C5_111 38 72 6.42888e-17
C5_112 40 72 6.42888e-17
R5_12 36 38 26
C5_121 36 72 6.42888e-17
C5_122 38 72 6.42888e-17
R5_13 41 43 26
C5_131 41 72 6.42888e-17
C5_132 43 72 6.42888e-17
R5_14 39 41 13
C5_141 39 72 5.3574e-17
C5_142 41 72 5.3574e-17
R5_15 37 39 26
C5_151 37 72 6.42888e-17
C5_152 39 72 6.42888e-17
R5_16 34 37 26
C5_161 34 72 6.42888e-17
C5_162 37 72 6.42888e-17
R2_1 57 56 15
R2_2 68 65 15
R2_3 66 65 15
R2_4 69 65 15
R2_5 67 65 15
R2_6 54 52 15
R2_7 60 62 15
R2_8 60 64 912
C2_81 60 72 1.59459e-16
C2_82 64 72 1.59459e-16
R2_9 60 63 912
C2_91 60 72 1.59459e-16
C2_92 63 72 1.59459e-16
R2_10 61 62 26
C2_101 61 72 6.42888e-17
C2_102 62 72 6.42888e-17
R2_11 54 55 13
C2_111 54 72 5.3574e-17
C2_112 55 72 5.3574e-17
R2_12 68 69 13
C2_121 68 72 5.3574e-17
C2_122 69 72 5.3574e-17
R2_13 66 68 26
C2_131 66 72 6.42888e-17
C2_132 68 72 6.42888e-17
R2_14 67 66 26
C2_141 67 72 6.42888e-17
C2_142 66 72 6.42888e-17
R2_15 53 67 65
C2_151 53 72 1.71437e-16
C2_152 67 72 1.71437e-16
R2_16 59 61 26
C2_161 59 72 6.42888e-17
C2_162 61 72 6.42888e-17
R2_17 58 59 13
C2_171 58 72 3.21444e-17
C2_172 59 72 3.21444e-17
R2_18 55 58 52
C2_181 55 72 1.28578e-16
C2_182 58 72 1.28578e-16
R2_19 53 55 26
C2_191 53 72 6.42888e-17
C2_192 55 72 6.42888e-17
R2_20 57 58 13
C2_201 57 72 5.3574e-17
C2_202 58 72 5.3574e-17
R1_1 81 77 15
R1_2 78 77 7.5
R1_3 82 79 15
R1_4 80 79 7.5
R1_5 76 75 15
R1_6 74 73 15
R1_7 72 74 26
C1_71 72 72 6.42888e-17
C1_72 74 72 6.42888e-17
R1_8 72 76 26
C1_81 72 72 6.42888e-17
C1_82 76 72 6.42888e-17
R1_9 80 82 26
C1_91 80 72 6.42888e-17
C1_92 82 72 6.42888e-17
R1_10 72 80 26
C1_101 72 72 6.42888e-17
C1_102 80 72 6.42888e-17
R1_11 78 81 26
C1_111 78 72 6.42888e-17
C1_112 81 72 6.42888e-17
R1_12 72 78 26
C1_121 72 72 6.42888e-17
C1_122 78 72 6.42888e-17
.ends o4_x4
