* Spice description of noa22_x1
* Spice driver version 1385040813
* Date ( dd/mm/yyyy hh:mm:ss ):  8/05/2026 at 14:23:17

* INTERF i0 i1 i2 nq vdd vss

.subckt noa22_x1 1 13 8 39 21 31
* NET 1 = i0
* NET 8 = i2
* NET 13 = i1
* NET 21 = vdd
* NET 31 = vss
* NET 39 = nq
Mtr_00006 19 9 25 21 sky130_fd_pr__pfet_01v8__model L=0.15U W=2.46U AS=0.7134P AD=0.7134P PS=5.5U PD=5.5U
Mtr_00005 40 4 24 21 sky130_fd_pr__pfet_01v8__model L=0.15U W=2.46U AS=0.7134P AD=0.7134P PS=5.5U PD=5.5U
Mtr_00004 25 16 40 21 sky130_fd_pr__pfet_01v8__model L=0.15U W=2.46U AS=0.7134P AD=0.7134P PS=5.5U PD=5.5U
Mtr_00003 32 2 44 31 sky130_fd_pr__nfet_01v8__model L=0.15U W=1.26U AS=0.3654P AD=0.3654P PS=3.1U PD=3.1U
Mtr_00002 44 14 38 31 sky130_fd_pr__nfet_01v8__model L=0.15U W=1.26U AS=0.3654P AD=0.3654P PS=3.1U PD=3.1U
Mtr_00001 38 7 33 31 sky130_fd_pr__nfet_01v8__model L=0.15U W=1.26U AS=0.3654P AD=0.3654P PS=3.1U PD=3.1U
R8_1 3 1 15
R8_2 3 4 576
C8_21 3 31 9.98634e-17
C8_22 4 31 9.98634e-17
R8_3 2 3 384
C8_31 2 31 6.76494e-17
C8_32 3 31 6.76494e-17
R7_1 10 8 15
R7_2 10 9 576
C7_21 10 31 9.98634e-17
C7_22 9 31 9.98634e-17
R7_3 7 10 384
C7_31 7 31 6.76494e-17
C7_32 10 31 6.76494e-17
R6_1 15 13 15
R6_2 15 16 576
C6_21 15 31 9.98634e-17
C6_22 16 31 9.98634e-17
R6_3 14 15 384
C6_31 14 31 6.76494e-17
C6_32 15 31 6.76494e-17
R5_1 20 19 15
R5_2 20 21 26
C5_21 20 31 6.42888e-17
C5_22 21 31 6.42888e-17
R4_1 28 25 15
R4_2 27 24 15
R4_3 26 24 15
R4_4 26 27 13
C4_41 26 31 5.3574e-17
C4_42 27 31 5.3574e-17
R4_5 27 28 52
C4_51 27 31 1.28578e-16
C4_52 28 31 1.28578e-16
R3_1 34 32 15
R3_2 35 33 15
R3_3 31 35 26
C3_31 31 31 6.42888e-17
C3_32 35 31 6.42888e-17
R3_4 31 34 26
C3_41 31 31 6.42888e-17
C3_42 34 31 6.42888e-17
R2_1 39 38 15
R2_2 41 40 15
R2_3 41 39 26
C2_31 41 31 6.42888e-17
C2_32 39 31 6.42888e-17
.ends noa22_x1
