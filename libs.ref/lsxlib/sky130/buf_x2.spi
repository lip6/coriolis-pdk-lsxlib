* Spice description of buf_x2
* Spice driver version 1724238765
* Date ( dd/mm/yyyy hh:mm:ss ):  8/05/2026 at 14:23:17

* INTERF i q vdd vss

.subckt buf_x2 1 32 9 12
* NET 1 = i
* NET 9 = vdd
* NET 12 = vss
* NET 32 = q
Mtr_00004 7 4 25 9 sky130_fd_pr__pfet_01v8__model L=0.15U W=1.02U AS=0.2958P AD=0.2958P PS=2.62U PD=2.62U
Mtr_00003 33 24 7 9 sky130_fd_pr__pfet_01v8__model L=0.15U W=2.46U AS=0.7134P AD=0.7134P PS=5.5U PD=5.5U
Mtr_00002 17 2 13 12 sky130_fd_pr__nfet_01v8__model L=0.15U W=0.54U AS=0.1566P AD=0.1566P PS=1.66U PD=1.66U
Mtr_00001 13 21 31 12 sky130_fd_pr__nfet_01v8__model L=0.15U W=1.26U AS=0.3654P AD=0.3654P PS=3.1U PD=3.1U
R5_1 3 1 15
R5_2 3 4 720
C5_21 3 12 1.25635e-16
C5_22 4 12 1.25635e-16
R5_3 2 3 576
C5_31 2 12 9.98634e-17
C5_32 3 12 9.98634e-17
R4_1 8 7 15
R4_2 8 9 26
C4_21 8 12 6.42888e-17
C4_22 9 12 6.42888e-17
R3_1 14 13 15
R3_2 12 14 26
C3_21 12 12 6.42888e-17
C3_22 14 12 6.42888e-17
R2_1 18 17 15
R2_2 23 22 15
R2_3 28 25 15
R2_4 23 24 480
C2_41 23 12 8.69778e-17
C2_42 24 12 8.69778e-17
R2_5 21 23 480
C2_51 21 12 8.0535e-17
C2_52 23 12 8.0535e-17
R2_6 26 28 13
C2_61 26 12 5.3574e-17
C2_62 28 12 5.3574e-17
R2_7 26 27 26
C2_71 26 12 7.50036e-17
C2_72 27 12 7.50036e-17
R2_8 22 27 78
C2_81 22 12 1.82152e-16
C2_82 27 12 1.82152e-16
R2_9 20 22 52
C2_91 20 12 1.17863e-16
C2_92 22 12 1.17863e-16
R2_10 19 20 26
C2_101 19 12 7.50036e-17
C2_102 20 12 7.50036e-17
R2_11 18 19 13
C2_111 18 12 5.3574e-17
C2_112 19 12 5.3574e-17
R1_1 32 31 7.5
R1_2 32 33 3.75
.ends buf_x2
