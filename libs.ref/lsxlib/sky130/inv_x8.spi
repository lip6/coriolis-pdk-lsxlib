* Spice description of inv_x8
* Spice driver version -1111561299
* Date ( dd/mm/yyyy hh:mm:ss ):  8/05/2026 at 14:22:51

* INTERF i nq vdd vss

.subckt inv_x8 1 43 26 29
* NET 1 = i
* NET 26 = vdd
* NET 29 = vss
* NET 43 = nq
Mtr_00008 16 10 48 26 sky130_fd_pr__pfet_01v8__model L=0.15U W=2.46U AS=0.7134P AD=0.7134P PS=5.5U PD=5.5U
Mtr_00007 48 9 14 26 sky130_fd_pr__pfet_01v8__model L=0.15U W=2.46U AS=0.7134P AD=0.7134P PS=5.5U PD=5.5U
Mtr_00006 14 8 46 26 sky130_fd_pr__pfet_01v8__model L=0.15U W=2.46U AS=0.7134P AD=0.7134P PS=5.5U PD=5.5U
Mtr_00005 46 6 13 26 sky130_fd_pr__pfet_01v8__model L=0.15U W=2.46U AS=0.7134P AD=0.7134P PS=5.5U PD=5.5U
Mtr_00004 40 3 32 29 sky130_fd_pr__nfet_01v8__model L=0.15U W=1.26U AS=0.3654P AD=0.3654P PS=3.1U PD=3.1U
Mtr_00003 30 2 40 29 sky130_fd_pr__nfet_01v8__model L=0.15U W=1.26U AS=0.3654P AD=0.3654P PS=3.1U PD=3.1U
Mtr_00002 42 5 34 29 sky130_fd_pr__nfet_01v8__model L=0.15U W=1.26U AS=0.3654P AD=0.3654P PS=3.1U PD=3.1U
Mtr_00001 32 4 42 29 sky130_fd_pr__nfet_01v8__model L=0.15U W=1.26U AS=0.3654P AD=0.3654P PS=3.1U PD=3.1U
R4_1 7 1 15
R4_2 7 9 576
C4_21 7 29 9.98634e-17
C4_22 9 29 9.98634e-17
R4_3 4 7 384
C4_31 4 29 6.76494e-17
C4_32 7 29 6.76494e-17
R4_4 7 8 576
C4_41 7 29 9.98634e-17
C4_42 8 29 9.98634e-17
R4_5 3 7 384
C4_51 3 29 6.76494e-17
C4_52 7 29 6.76494e-17
R4_6 7 6 576
C4_61 7 29 9.98634e-17
C4_62 6 29 9.98634e-17
R4_7 2 7 384
C4_71 2 29 6.76494e-17
C4_72 7 29 6.76494e-17
R4_8 7 10 576
C4_81 7 29 9.98634e-17
C4_82 10 29 9.98634e-17
R4_9 5 7 384
C4_91 5 29 6.76494e-17
C4_92 7 29 6.76494e-17
R3_1 16 25 15
R3_2 16 19 15
R3_3 16 22 15
R3_4 16 17 15
R3_5 23 13 15
R3_6 20 13 15
R3_7 24 14 15
R3_8 18 14 15
R3_9 21 14 15
R3_10 15 14 15
R3_11 24 26 26
C3_111 24 29 6.42888e-17
C3_112 26 29 6.42888e-17
R3_12 21 24 13
C3_121 21 29 5.3574e-17
C3_122 24 29 5.3574e-17
R3_13 18 21 26
C3_131 18 29 6.42888e-17
C3_132 21 29 6.42888e-17
R3_14 15 18 26
C3_141 15 29 6.42888e-17
C3_142 18 29 6.42888e-17
R3_15 23 26 26
C3_151 23 29 6.42888e-17
C3_152 26 29 6.42888e-17
R3_16 20 23 13
C3_161 20 29 5.3574e-17
C3_162 23 29 5.3574e-17
R3_17 25 26 26
C3_171 25 29 6.42888e-17
C3_172 26 29 6.42888e-17
R3_18 22 25 13
C3_181 22 29 5.3574e-17
C3_182 25 29 5.3574e-17
R3_19 19 22 26
C3_191 19 29 6.42888e-17
C3_192 22 29 6.42888e-17
R3_20 17 19 26
C3_201 17 29 6.42888e-17
C3_202 19 29 6.42888e-17
R2_1 37 34 15
R2_2 35 34 15
R2_3 31 30 15
R2_4 36 32 15
R2_5 33 32 15
R2_6 33 36 26
C2_61 33 29 7.50036e-17
C2_62 36 29 7.50036e-17
R2_7 29 33 26
C2_71 29 29 6.42888e-17
C2_72 33 29 6.42888e-17
R2_8 29 31 26
C2_81 29 29 6.42888e-17
C2_82 31 29 6.42888e-17
R2_9 35 37 26
C2_91 35 29 7.50036e-17
C2_92 37 29 7.50036e-17
R2_10 29 35 26
C2_101 29 29 6.42888e-17
C2_102 35 29 6.42888e-17
R1_1 43 42 7.5
R1_2 43 48 3.75
R1_3 51 46 15
R1_4 50 46 15
R1_5 49 46 15
R1_6 47 46 15
R1_7 41 40 15
R1_8 44 40 15
R1_9 50 51 13
C1_91 50 29 5.3574e-17
C1_92 51 29 5.3574e-17
R1_10 49 50 26
C1_101 49 29 6.42888e-17
C1_102 50 29 6.42888e-17
R1_11 47 49 26
C1_111 47 29 6.42888e-17
C1_112 49 29 6.42888e-17
R1_12 45 47 26
C1_121 45 29 7.50036e-17
C1_122 47 29 7.50036e-17
R1_13 44 45 26
C1_131 44 29 7.50036e-17
C1_132 45 29 7.50036e-17
R1_14 41 44 26
C1_141 41 29 7.50036e-17
C1_142 44 29 7.50036e-17
R1_15 45 43 52
C1_151 45 29 1.28578e-16
C1_152 43 29 1.28578e-16
.ends inv_x8
