* Spice description of no2_x1
* Spice driver version -907240531
* Date ( dd/mm/yyyy hh:mm:ss ):  8/05/2026 at 14:22:51

* INTERF i0 i1 nq vdd vss

.subckt no2_x1 6 2 21 14 27
* NET 2 = i1
* NET 6 = i0
* NET 14 = vdd
* NET 21 = nq
* NET 27 = vss
Mtr_00004 11 3 17 14 sky130_fd_pr__pfet_01v8__model L=0.15U W=2.46U AS=0.7134P AD=0.7134P PS=5.5U PD=5.5U
Mtr_00003 17 8 22 14 sky130_fd_pr__pfet_01v8__model L=0.15U W=2.46U AS=0.7134P AD=0.7134P PS=5.5U PD=5.5U
Mtr_00002 20 1 30 27 sky130_fd_pr__nfet_01v8__model L=0.15U W=0.66U AS=0.1914P AD=0.1914P PS=1.9U PD=1.9U
Mtr_00001 28 7 20 27 sky130_fd_pr__nfet_01v8__model L=0.15U W=0.66U AS=0.1914P AD=0.1914P PS=1.9U PD=1.9U
R6_1 3 2 15
R6_2 1 3 1008
C6_21 1 27 1.75566e-16
C6_22 3 27 1.75566e-16
R5_1 8 6 15
R5_2 7 8 1008
C5_21 7 27 1.75566e-16
C5_22 8 27 1.75566e-16
R4_1 13 11 15
R4_2 12 11 15
R4_3 13 14 26
C4_31 13 27 6.42888e-17
C4_32 14 27 6.42888e-17
R4_4 12 13 13
C4_41 12 27 5.3574e-17
C4_42 13 27 5.3574e-17
R2_1 21 20 15
R2_2 23 22 15
R2_3 24 22 15
R2_4 24 21 26
C2_41 24 27 6.42888e-17
C2_42 21 27 6.42888e-17
R2_5 23 21 26
C2_51 23 27 6.42888e-17
C2_52 21 27 6.42888e-17
R1_1 31 30 15
R1_2 29 28 15
R1_3 27 29 26
C1_31 27 27 6.42888e-17
C1_32 29 27 6.42888e-17
R1_4 27 31 26
C1_41 27 27 6.42888e-17
C1_42 31 27 6.42888e-17
.ends no2_x1
