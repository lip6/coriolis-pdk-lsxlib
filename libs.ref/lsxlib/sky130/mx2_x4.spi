* Spice description of mx2_x4
* Spice driver version 836373421
* Date ( dd/mm/yyyy hh:mm:ss ):  8/05/2026 at 14:22:51

* INTERF cmd i0 i1 q vdd vss

.subckt mx2_x4 31 40 49 23 19 56
* NET 19 = vdd
* NET 23 = q
* NET 31 = cmd
* NET 40 = i0
* NET 49 = i1
* NET 56 = vss
Mtr_00014 9 81 24 19 sky130_fd_pr__pfet_01v8__model L=0.15U W=2.46U AS=0.7134P AD=0.7134P PS=5.5U PD=5.5U
Mtr_00013 13 45 1 19 sky130_fd_pr__pfet_01v8__model L=0.15U W=1.26U AS=0.3654P AD=0.3654P PS=3.1U PD=3.1U
Mtr_00012 24 80 7 19 sky130_fd_pr__pfet_01v8__model L=0.15U W=2.46U AS=0.7134P AD=0.7134P PS=5.5U PD=5.5U
Mtr_00011 1 36 82 19 sky130_fd_pr__pfet_01v8__model L=0.15U W=1.26U AS=0.3654P AD=0.3654P PS=3.1U PD=3.1U
Mtr_00010 82 96 4 19 sky130_fd_pr__pfet_01v8__model L=0.15U W=1.26U AS=0.3654P AD=0.3654P PS=3.1U PD=3.1U
Mtr_00009 98 34 13 19 sky130_fd_pr__pfet_01v8__model L=0.15U W=1.02U AS=0.2958P AD=0.2958P PS=2.62U PD=2.62U
Mtr_00008 4 53 7 19 sky130_fd_pr__pfet_01v8__model L=0.15U W=1.26U AS=0.3654P AD=0.3654P PS=3.1U PD=3.1U
Mtr_00007 70 93 67 56 sky130_fd_pr__nfet_01v8__model L=0.15U W=0.66U AS=0.1914P AD=0.1914P PS=1.9U PD=1.9U
Mtr_00006 67 43 57 56 sky130_fd_pr__nfet_01v8__model L=0.15U W=0.66U AS=0.1914P AD=0.1914P PS=1.9U PD=1.9U
Mtr_00005 86 28 70 56 sky130_fd_pr__nfet_01v8__model L=0.15U W=0.66U AS=0.1914P AD=0.1914P PS=1.9U PD=1.9U
Mtr_00004 57 27 89 56 sky130_fd_pr__nfet_01v8__model L=0.15U W=0.54U AS=0.1566P AD=0.1566P PS=1.66U PD=1.66U
Mtr_00003 22 72 59 56 sky130_fd_pr__nfet_01v8__model L=0.15U W=1.26U AS=0.3654P AD=0.3654P PS=3.1U PD=3.1U
Mtr_00002 59 51 86 56 sky130_fd_pr__nfet_01v8__model L=0.15U W=0.66U AS=0.1914P AD=0.1914P PS=1.9U PD=1.9U
Mtr_00001 61 73 22 56 sky130_fd_pr__nfet_01v8__model L=0.15U W=1.26U AS=0.3654P AD=0.3654P PS=3.1U PD=3.1U
R10_1 15 9 15
R10_2 12 9 15
R10_3 18 9 15
R10_4 9 10 15
R10_5 17 7 15
R10_6 11 7 15
R10_7 14 7 15
R10_8 8 7 15
R10_9 16 13 15
R10_10 16 19 26
C10_101 16 56 6.42888e-17
C10_102 19 56 6.42888e-17
R10_11 17 19 26
C10_111 17 56 6.42888e-17
C10_112 19 56 6.42888e-17
R10_12 14 17 26
C10_121 14 56 6.42888e-17
C10_122 17 56 6.42888e-17
R10_13 11 14 26
C10_131 11 56 6.42888e-17
C10_132 14 56 6.42888e-17
R10_14 8 11 13
C10_141 8 56 5.3574e-17
C10_142 11 56 5.3574e-17
R10_15 18 19 26
C10_151 18 56 6.42888e-17
C10_152 19 56 6.42888e-17
R10_16 15 18 26
C10_161 15 56 6.42888e-17
C10_162 18 56 6.42888e-17
R10_17 12 15 26
C10_171 12 56 6.42888e-17
C10_172 15 56 6.42888e-17
R10_18 10 12 13
C10_181 10 56 5.3574e-17
C10_182 12 56 5.3574e-17
R9_1 23 22 7.5
R9_2 23 24 3.75
R8_1 32 31 15
R8_2 37 36 480
C8_21 37 56 8.0535e-17
C8_22 36 56 8.0535e-17
R8_3 35 37 96
C8_31 35 56 1.93284e-17
C8_32 37 56 1.93284e-17
R8_4 30 34 768
C8_41 30 56 1.36104e-16
C8_42 34 56 1.36104e-16
R8_5 27 30 480
C8_51 27 56 8.45618e-17
C8_52 30 56 8.45618e-17
R8_6 32 35 240
C8_61 32 56 4.5905e-17
C8_62 35 56 4.5905e-17
R8_7 32 33 240
C8_71 32 56 4.50996e-17
C8_72 33 56 4.50996e-17
R8_8 30 32 336
C8_81 30 56 5.79852e-17
C8_82 32 56 5.79852e-17
R8_9 29 33 336
C8_91 29 56 5.79852e-17
C8_92 33 56 5.79852e-17
R8_10 29 28 48
C8_101 29 56 1.28856e-17
C8_102 28 56 1.28856e-17
R7_1 41 40 15
R7_2 44 40 15
R7_3 46 45 288
C7_31 46 56 4.8321e-17
C7_32 45 56 4.8321e-17
R7_4 44 46 96
C7_41 44 56 1.93284e-17
C7_42 46 56 1.93284e-17
R7_5 42 43 48
C7_51 42 56 1.28856e-17
C7_52 43 56 1.28856e-17
R7_6 42 41 192
C7_61 42 56 3.2214e-17
C7_62 41 56 3.2214e-17
R6_1 52 49 15
R6_2 50 49 15
R6_3 51 50 336
C6_31 51 56 5.79852e-17
C6_32 50 56 5.79852e-17
R6_4 52 53 480
C6_41 52 56 8.0535e-17
C6_42 53 56 8.0535e-17
R5_1 58 57 15
R5_2 62 61 15
R5_3 64 61 15
R5_4 63 59 15
R5_5 60 59 15
R5_6 60 63 26
C5_61 60 56 7.50036e-17
C5_62 63 56 7.50036e-17
R5_7 56 60 26
C5_71 56 56 6.42888e-17
C5_72 60 56 6.42888e-17
R5_8 62 64 26
C5_81 62 56 7.50036e-17
C5_82 64 56 7.50036e-17
R5_9 56 62 26
C5_91 56 56 6.42888e-17
C5_92 62 56 6.42888e-17
R5_10 56 58 26
C5_101 56 56 6.42888e-17
C5_102 58 56 6.42888e-17
R3_1 71 70 15
R3_2 78 77 15
R3_3 83 82 15
R3_4 76 81 528
C3_41 76 56 9.34206e-17
C3_42 81 56 9.34206e-17
R3_5 73 76 432
C3_51 73 56 7.40922e-17
C3_52 76 56 7.40922e-17
R3_6 75 76 192
C3_61 75 56 3.86568e-17
C3_62 76 56 3.86568e-17
R3_7 75 80 528
C3_71 75 56 9.34206e-17
C3_72 80 56 9.34206e-17
R3_8 72 75 432
C3_81 72 56 7.40922e-17
C3_82 75 56 7.40922e-17
R3_9 74 75 288
C3_91 74 56 5.15424e-17
C3_92 75 56 5.15424e-17
R3_10 74 79 96
C3_101 74 56 1.93284e-17
C3_102 79 56 1.93284e-17
R3_11 78 79 192
C3_111 78 56 3.86568e-17
C3_112 79 56 3.86568e-17
R3_12 77 83 65
C3_121 77 56 1.60722e-16
C3_122 83 56 1.60722e-16
R3_13 71 77 78
C3_131 71 56 1.92866e-16
C3_132 77 56 1.92866e-16
R1_1 90 89 15
R1_2 99 98 15
R1_3 101 98 15
R1_4 95 94 15
R1_5 96 97 15
R1_6 93 95 336
C1_61 93 56 5.79852e-17
C1_62 95 56 5.79852e-17
R1_7 97 103 52
C1_71 97 56 1.17863e-16
C1_72 103 56 1.17863e-16
R1_8 102 103 52
C1_81 102 56 1.17863e-16
C1_82 103 56 1.17863e-16
R1_9 92 94 13
C1_91 92 56 5.3574e-17
C1_92 94 56 5.3574e-17
R1_10 100 102 13
C1_101 100 56 5.3574e-17
C1_102 102 56 5.3574e-17
R1_11 91 92 52
C1_111 91 56 1.28578e-16
C1_112 92 56 1.28578e-16
R1_12 99 100 52
C1_121 99 56 1.17863e-16
C1_122 100 56 1.17863e-16
R1_13 99 101 13
C1_131 99 56 5.3574e-17
C1_132 101 56 5.3574e-17
R1_14 91 99 130
C1_141 91 56 3.00014e-16
C1_142 99 56 3.00014e-16
R1_15 90 91 13
C1_151 90 56 5.3574e-17
C1_152 91 56 5.3574e-17
.ends mx2_x4
