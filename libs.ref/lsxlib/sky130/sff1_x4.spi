* Spice description of sff1_x4
* Spice driver version -10175571
* Date ( dd/mm/yyyy hh:mm:ss ):  8/05/2026 at 14:22:51

* INTERF ck i q vdd vss

.subckt sff1_x4 100 105 32 27 109
* NET 27 = vdd
* NET 32 = q
* NET 50 = sff_m
* NET 67 = sff_s
* NET 83 = y
* NET 100 = ck
* NET 105 = i
* NET 109 = vss
* NET 124 = ckr
* NET 152 = nckr
* NET 179 = u
Mtr_00026 170 101 15 27 sky130_fd_pr__pfet_01v8__model L=0.15U W=1.26U AS=0.3654P AD=0.3654P PS=3.1U PD=3.1U
Mtr_00025 15 171 147 27 sky130_fd_pr__pfet_01v8__model L=0.15U W=1.26U AS=0.3654P AD=0.3654P PS=3.1U PD=3.1U
Mtr_00024 1 38 10 27 sky130_fd_pr__pfet_01v8__model L=0.15U W=1.26U AS=0.3654P AD=0.3654P PS=3.1U PD=3.1U
Mtr_00023 93 174 77 27 sky130_fd_pr__pfet_01v8__model L=0.15U W=1.02U AS=0.2958P AD=0.2958P PS=2.62U PD=2.62U
Mtr_00022 77 142 1 27 sky130_fd_pr__pfet_01v8__model L=0.15U W=1.26U AS=0.3654P AD=0.3654P PS=3.1U PD=3.1U
Mtr_00021 93 63 17 27 sky130_fd_pr__pfet_01v8__model L=0.15U W=1.02U AS=0.2958P AD=0.2958P PS=2.62U PD=2.62U
Mtr_00020 187 106 16 27 sky130_fd_pr__pfet_01v8__model L=0.15U W=1.02U AS=0.2958P AD=0.2958P PS=2.62U PD=2.62U
Mtr_00019 16 188 4 27 sky130_fd_pr__pfet_01v8__model L=0.15U W=1.02U AS=0.2958P AD=0.2958P PS=2.62U PD=2.62U
Mtr_00018 61 173 7 27 sky130_fd_pr__pfet_01v8__model L=0.15U W=1.02U AS=0.2958P AD=0.2958P PS=2.62U PD=2.62U
Mtr_00017 7 91 17 27 sky130_fd_pr__pfet_01v8__model L=0.15U W=1.02U AS=0.2958P AD=0.2958P PS=2.62U PD=2.62U
Mtr_00016 4 140 61 27 sky130_fd_pr__pfet_01v8__model L=0.15U W=1.02U AS=0.2958P AD=0.2958P PS=2.62U PD=2.62U
Mtr_00015 37 76 11 27 sky130_fd_pr__pfet_01v8__model L=0.15U W=2.46U AS=0.7134P AD=0.7134P PS=5.5U PD=5.5U
Mtr_00014 10 75 37 27 sky130_fd_pr__pfet_01v8__model L=0.15U W=2.46U AS=0.7134P AD=0.7134P PS=5.5U PD=5.5U
Mtr_00013 116 30 41 109 sky130_fd_pr__nfet_01v8__model L=0.15U W=0.66U AS=0.1914P AD=0.1914P PS=1.9U PD=1.9U
Mtr_00012 112 104 179 109 sky130_fd_pr__nfet_01v8__model L=0.15U W=0.54U AS=0.1566P AD=0.1566P PS=1.66U PD=1.66U
Mtr_00011 67 127 86 109 sky130_fd_pr__nfet_01v8__model L=0.15U W=0.54U AS=0.1566P AD=0.1566P PS=1.66U PD=1.66U
Mtr_00010 86 52 114 109 sky130_fd_pr__nfet_01v8__model L=0.15U W=0.54U AS=0.1566P AD=0.1566P PS=1.66U PD=1.66U
Mtr_00009 114 83 44 109 sky130_fd_pr__nfet_01v8__model L=0.15U W=0.54U AS=0.1566P AD=0.1566P PS=1.66U PD=1.66U
Mtr_00008 44 126 50 109 sky130_fd_pr__nfet_01v8__model L=0.15U W=0.54U AS=0.1566P AD=0.1566P PS=1.66U PD=1.66U
Mtr_00007 50 155 47 109 sky130_fd_pr__nfet_01v8__model L=0.15U W=0.54U AS=0.1566P AD=0.1566P PS=1.66U PD=1.66U
Mtr_00006 47 181 112 109 sky130_fd_pr__nfet_01v8__model L=0.15U W=0.54U AS=0.1566P AD=0.1566P PS=1.66U PD=1.66U
Mtr_00005 41 157 67 109 sky130_fd_pr__nfet_01v8__model L=0.15U W=0.66U AS=0.1914P AD=0.1914P PS=1.9U PD=1.9U
Mtr_00004 31 70 116 109 sky130_fd_pr__nfet_01v8__model L=0.15U W=1.26U AS=0.3654P AD=0.3654P PS=3.1U PD=3.1U
Mtr_00003 118 71 31 109 sky130_fd_pr__nfet_01v8__model L=0.15U W=1.26U AS=0.3654P AD=0.3654P PS=3.1U PD=3.1U
Mtr_00002 124 153 110 109 sky130_fd_pr__nfet_01v8__model L=0.15U W=0.66U AS=0.1914P AD=0.1914P PS=1.9U PD=1.9U
Mtr_00001 110 99 152 109 sky130_fd_pr__nfet_01v8__model L=0.15U W=0.66U AS=0.1914P AD=0.1914P PS=1.9U PD=1.9U
R14_1 13 10 15
R14_2 18 10 15
R14_3 25 10 15
R14_4 26 11 15
R14_5 19 11 15
R14_6 14 11 15
R14_7 12 11 15
R14_8 23 16 15
R14_9 20 16 15
R14_10 21 17 15
R14_11 24 17 15
R14_12 22 15 15
R14_13 22 27 26
C14_131 22 109 6.42888e-17
C14_132 27 109 6.42888e-17
R14_14 24 27 26
C14_141 24 109 6.42888e-17
C14_142 27 109 6.42888e-17
R14_15 21 24 13
C14_151 21 109 4.28592e-17
C14_152 24 109 4.28592e-17
R14_16 23 27 26
C14_161 23 109 6.42888e-17
C14_162 27 109 6.42888e-17
R14_17 20 23 13
C14_171 20 109 4.28592e-17
C14_172 23 109 4.28592e-17
R14_18 26 27 26
C14_181 26 109 7.50036e-17
C14_182 27 109 7.50036e-17
R14_19 19 26 13
C14_191 19 109 5.3574e-17
C14_192 26 109 5.3574e-17
R14_20 14 19 13
C14_201 14 109 5.3574e-17
C14_202 19 109 5.3574e-17
R14_21 12 14 13
C14_211 12 109 5.3574e-17
C14_212 14 109 5.3574e-17
R14_22 25 27 26
C14_221 25 109 7.50036e-17
C14_222 27 109 7.50036e-17
R14_23 18 25 26
C14_231 18 109 6.42888e-17
C14_232 25 109 6.42888e-17
R14_24 13 18 26
C14_241 13 109 7.50036e-17
C14_242 18 109 7.50036e-17
R13_1 32 31 7.5
R13_2 32 37 3.75
R13_3 36 35 15
R13_4 34 33 15
R13_5 30 34 288
C13_51 30 109 5.15424e-17
C13_52 34 109 5.15424e-17
R13_6 36 38 576
C13_61 36 109 9.98634e-17
C13_62 38 109 9.98634e-17
R13_7 33 32 52
C13_71 33 109 1.17863e-16
C13_72 32 109 1.17863e-16
R13_8 35 32 52
C13_81 35 109 1.17863e-16
C13_82 32 109 1.17863e-16
R9_1 51 50 15
R9_2 55 54 15
R9_3 59 58 15
R9_4 62 61 15
R9_5 64 61 15
R9_6 62 64 13
C9_61 62 109 4.28592e-17
C9_62 64 109 4.28592e-17
R9_7 60 63 432
C9_71 60 109 7.40922e-17
C9_72 63 109 7.40922e-17
R9_8 57 62 39
C9_81 57 109 1.07148e-16
C9_82 62 109 1.07148e-16
R9_9 59 60 192
C9_91 59 109 3.86568e-17
C9_92 60 109 3.86568e-17
R9_10 52 56 336
C9_101 52 109 6.12066e-17
C9_102 56 109 6.12066e-17
R9_11 57 58 26
C9_111 57 109 6.42888e-17
C9_112 58 109 6.42888e-17
R9_12 55 56 192
C9_121 55 109 3.86568e-17
C9_122 56 109 3.86568e-17
R9_13 54 58 65
C9_131 54 109 1.50007e-16
C9_132 58 109 1.50007e-16
R9_14 53 54 26
C9_141 53 109 6.42888e-17
C9_142 54 109 6.42888e-17
R9_15 51 53 39
C9_151 51 109 1.07148e-16
C9_152 53 109 1.07148e-16
R8_1 68 67 15
R8_2 79 77 15
R8_3 74 73 15
R8_4 80 77 15
R8_5 74 76 576
C8_51 74 109 9.98634e-17
C8_52 76 109 9.98634e-17
R8_6 71 74 384
C8_61 71 109 6.76494e-17
C8_62 74 109 6.76494e-17
R8_7 74 75 576
C8_71 74 109 9.98634e-17
C8_72 75 109 9.98634e-17
R8_8 70 74 384
C8_81 70 109 6.76494e-17
C8_82 74 109 6.76494e-17
R8_9 79 80 13
C8_91 79 109 4.28592e-17
C8_92 80 109 4.28592e-17
R8_10 72 73 52
C8_101 72 109 1.17863e-16
C8_102 73 109 1.17863e-16
R8_11 79 78 13
C8_111 79 109 4.28592e-17
C8_112 78 109 4.28592e-17
R8_12 72 78 91
C8_121 72 109 2.14296e-16
C8_122 78 109 2.14296e-16
R8_13 69 72 65
C8_131 69 109 1.50007e-16
C8_132 72 109 1.50007e-16
R8_14 68 69 13
C8_141 68 109 4.28592e-17
C8_142 69 109 4.28592e-17
R7_1 87 86 15
R7_2 83 84 15
R7_3 96 93 15
R7_4 94 93 15
R7_5 91 92 15
R7_6 92 95 39
C7_61 92 109 9.64332e-17
C7_62 95 109 9.64332e-17
R7_7 94 96 13
C7_71 94 109 4.28592e-17
C7_72 96 109 4.28592e-17
R7_8 95 94 13
C7_81 95 109 5.3574e-17
C7_82 94 109 5.3574e-17
R7_9 90 95 52
C7_91 90 109 1.17863e-16
C7_92 95 109 1.17863e-16
R7_10 89 90 13
C7_101 89 109 4.28592e-17
C7_102 90 109 4.28592e-17
R7_11 85 89 52
C7_111 85 109 1.39292e-16
C7_112 89 109 1.39292e-16
R7_12 85 88 13
C7_121 85 109 4.28592e-17
C7_122 88 109 4.28592e-17
R7_13 84 85 13
C7_131 84 109 5.3574e-17
C7_132 85 109 5.3574e-17
R7_14 87 88 13
C7_141 87 109 5.3574e-17
C7_142 88 109 5.3574e-17
R6_1 99 100 15
R6_2 101 100 15
R5_1 104 105 15
R5_2 106 105 15
R4_1 111 110 15
R4_2 120 116 15
R4_3 117 116 15
R4_4 121 118 15
R4_5 119 118 15
R4_6 113 112 15
R4_7 115 114 15
R4_8 109 115 26
C4_81 109 109 6.42888e-17
C4_82 115 109 6.42888e-17
R4_9 109 113 26
C4_91 109 109 6.42888e-17
C4_92 113 109 6.42888e-17
R4_10 119 121 26
C4_101 119 109 6.42888e-17
C4_102 121 109 6.42888e-17
R4_11 109 119 26
C4_111 109 109 6.42888e-17
C4_112 119 109 6.42888e-17
R4_12 117 120 13
C4_121 117 109 4.28592e-17
C4_122 120 109 4.28592e-17
R4_13 109 117 26
C4_131 109 109 6.42888e-17
C4_132 117 109 6.42888e-17
R4_14 109 111 26
C4_141 109 109 6.42888e-17
C4_142 111 109 6.42888e-17
R3_1 125 124 15
R3_2 148 147 15
R3_3 149 147 15
R3_4 133 132 15
R3_5 136 135 15
R3_6 131 130 15
R3_7 140 141 15
R3_8 144 143 15
R3_9 145 142 288
C3_91 145 109 5.47638e-17
C3_92 142 109 5.47638e-17
R3_10 144 145 144
C3_101 144 109 2.57712e-17
C3_102 145 109 2.57712e-17
R3_11 143 146 13
C3_111 143 109 4.68772e-17
C3_112 146 109 4.68772e-17
R3_12 130 143 65
C3_121 130 109 1.50007e-16
C3_122 143 109 1.50007e-16
R3_13 138 141 52
C3_131 138 109 1.17863e-16
C3_132 141 109 1.17863e-16
R3_14 138 139 26
C3_141 138 109 6.42888e-17
C3_142 139 109 6.42888e-17
R3_15 131 137 144
C3_151 131 109 2.57712e-17
C3_152 137 109 2.57712e-17
R3_16 127 131 336
C3_161 127 109 6.12066e-17
C3_162 131 109 6.12066e-17
R3_17 135 139 13
C3_171 135 109 3.21444e-17
C3_172 139 109 3.21444e-17
R3_18 136 137 624
C3_181 136 109 1.09528e-16
C3_182 137 109 1.09528e-16
R3_19 129 136 192
C3_191 129 109 3.78515e-17
C3_192 136 109 3.78515e-17
R3_20 126 129 288
C3_201 126 109 5.47638e-17
C3_202 129 109 5.47638e-17
R3_21 128 129 768
C3_211 128 109 1.35299e-16
C3_212 129 109 1.35299e-16
R3_22 128 134 192
C3_221 128 109 3.2214e-17
C3_222 134 109 3.2214e-17
R3_23 133 134 192
C3_231 133 109 3.2214e-17
C3_232 134 109 3.2214e-17
R3_24 148 149 13
C3_241 148 109 5.3574e-17
C3_242 149 109 5.3574e-17
R3_25 132 148 78
C3_251 132 109 1.92866e-16
C3_252 148 109 1.92866e-16
R3_26 125 132 52
C3_261 125 109 1.39292e-16
C3_262 132 109 1.39292e-16
R2_1 154 152 15
R2_2 172 170 15
R2_3 176 170 15
R2_4 164 163 15
R2_5 161 162 15
R2_6 155 156 15
R2_7 153 159 336
C2_71 153 109 5.79852e-17
C2_72 159 109 5.79852e-17
R2_8 156 162 26
C2_81 156 109 8.57184e-17
C2_82 162 109 8.57184e-17
R2_9 160 159 144
C2_91 160 109 2.57712e-17
C2_92 159 109 2.57712e-17
R2_10 175 174 48
C2_101 175 109 1.28856e-17
C2_102 174 109 1.28856e-17
R2_11 158 157 48
C2_111 158 109 1.28856e-17
C2_112 157 109 1.28856e-17
R2_12 160 165 336
C2_121 160 109 5.79852e-17
C2_122 165 109 5.79852e-17
R2_13 166 171 576
C2_131 166 109 9.98634e-17
C2_132 171 109 9.98634e-17
R2_14 167 173 624
C2_141 167 109 1.06306e-16
C2_142 173 109 1.06306e-16
R2_15 168 175 384
C2_151 168 109 7.08708e-17
C2_152 175 109 7.08708e-17
R2_16 158 169 528
C2_161 158 109 9.01992e-17
C2_162 169 109 9.01992e-17
R2_17 168 169 192
C2_171 168 109 3.86568e-17
C2_172 169 109 3.86568e-17
R2_18 167 168 576
C2_181 167 109 9.6642e-17
C2_182 168 109 9.6642e-17
R2_19 161 167 192
C2_191 161 109 3.86568e-17
C2_192 167 109 3.86568e-17
R2_20 166 161 864
C2_201 166 109 1.48184e-16
C2_202 161 109 1.48184e-16
R2_21 165 166 144
C2_211 165 109 2.57712e-17
C2_212 166 109 2.57712e-17
R2_22 164 165 192
C2_221 164 109 3.2214e-17
C2_222 165 109 3.2214e-17
R2_23 172 176 13
C2_231 172 109 5.3574e-17
C2_232 176 109 5.3574e-17
R2_24 163 172 52
C2_241 163 109 1.39292e-16
C2_242 172 109 1.39292e-16
R2_25 154 163 78
C2_251 154 109 1.92866e-16
C2_252 163 109 1.92866e-16
R1_1 180 179 15
R1_2 189 187 15
R1_3 184 183 15
R1_4 190 187 15
R1_5 186 185 15
R1_6 181 182 15
R1_7 182 185 78
C1_71 182 109 2.03581e-16
C1_72 185 109 2.03581e-16
R1_8 186 188 432
C1_81 186 109 7.40922e-17
C1_82 188 109 7.40922e-17
R1_9 184 186 384
C1_91 184 109 6.4428e-17
C1_92 186 109 6.4428e-17
R1_10 189 190 13
C1_101 189 109 4.28592e-17
C1_102 190 109 4.28592e-17
R1_11 183 189 39
C1_111 183 109 1.07148e-16
C1_112 189 109 1.07148e-16
R1_12 180 183 104
C1_121 180 109 2.57155e-16
C1_122 183 109 2.57155e-16
.ends sff1_x4
