* Spice description of oa22_x4
* Spice driver version 1651735469
* Date ( dd/mm/yyyy hh:mm:ss ):  8/05/2026 at 14:23:17

* INTERF i0 i1 i2 q vdd vss

.subckt oa22_x4 8 21 17 45 41 65
* NET 8 = i0
* NET 17 = i2
* NET 21 = i1
* NET 41 = vdd
* NET 45 = q
* NET 65 = vss
Mtr_00010 31 58 46 41 sky130_fd_pr__pfet_01v8__model L=0.15U W=2.46U AS=0.7134P AD=0.7134P PS=5.5U PD=5.5U
Mtr_00009 46 59 33 41 sky130_fd_pr__pfet_01v8__model L=0.15U W=2.46U AS=0.7134P AD=0.7134P PS=5.5U PD=5.5U
Mtr_00008 3 28 60 41 sky130_fd_pr__pfet_01v8__model L=0.15U W=1.26U AS=0.3654P AD=0.3654P PS=3.1U PD=3.1U
Mtr_00007 31 18 3 41 sky130_fd_pr__pfet_01v8__model L=0.15U W=1.26U AS=0.3654P AD=0.3654P PS=3.1U PD=3.1U
Mtr_00006 60 13 1 41 sky130_fd_pr__pfet_01v8__model L=0.15U W=1.26U AS=0.3654P AD=0.3654P PS=3.1U PD=3.1U
Mtr_00005 44 55 70 65 sky130_fd_pr__nfet_01v8__model L=0.15U W=1.26U AS=0.3654P AD=0.3654P PS=3.1U PD=3.1U
Mtr_00004 44 54 68 65 sky130_fd_pr__nfet_01v8__model L=0.15U W=1.26U AS=0.3654P AD=0.3654P PS=3.1U PD=3.1U
Mtr_00003 66 10 49 65 sky130_fd_pr__nfet_01v8__model L=0.15U W=0.66U AS=0.1914P AD=0.1914P PS=1.9U PD=1.9U
Mtr_00002 49 23 53 65 sky130_fd_pr__nfet_01v8__model L=0.15U W=0.66U AS=0.1914P AD=0.1914P PS=1.9U PD=1.9U
Mtr_00001 53 16 68 65 sky130_fd_pr__nfet_01v8__model L=0.15U W=0.66U AS=0.1914P AD=0.1914P PS=1.9U PD=1.9U
R9_1 4 1 15
R9_2 2 1 15
R9_3 5 3 15
R9_4 4 5 52
C9_41 4 65 1.28578e-16
C9_42 5 65 1.28578e-16
R9_5 2 4 13
C9_51 2 65 5.3574e-17
C9_52 4 65 5.3574e-17
R8_1 11 8 15
R8_2 12 13 96
C8_21 12 65 1.93284e-17
C8_22 13 65 1.93284e-17
R8_3 11 12 480
C8_31 11 65 8.37564e-17
C8_32 12 65 8.37564e-17
R8_4 9 11 384
C8_41 9 65 6.4428e-17
C8_42 11 65 6.4428e-17
R8_5 9 10 96
C8_51 9 65 1.93284e-17
C8_52 10 65 1.93284e-17
R7_1 16 17 15
R7_2 18 17 15
R6_1 25 21 15
R6_2 23 24 336
C6_21 23 65 5.79852e-17
C6_22 24 65 5.79852e-17
R6_3 22 24 144
C6_31 22 65 2.57712e-17
C6_32 24 65 2.57712e-17
R6_4 25 26 192
C6_41 25 65 3.2214e-17
C6_42 26 65 3.2214e-17
R6_5 22 25 192
C6_51 22 65 3.2214e-17
C6_52 25 65 3.2214e-17
R6_6 26 27 144
C6_61 26 65 2.57712e-17
C6_62 27 65 2.57712e-17
R6_7 27 28 528
C6_71 27 65 9.34206e-17
C6_72 28 65 9.34206e-17
R5_1 31 32 15
R5_2 31 39 15
R5_3 31 35 15
R5_4 31 37 15
R5_5 36 33 15
R5_6 40 33 15
R5_7 38 33 15
R5_8 34 33 15
R5_9 40 41 26
C5_91 40 65 6.42888e-17
C5_92 41 65 6.42888e-17
R5_10 38 40 13
C5_101 38 65 5.3574e-17
C5_102 40 65 5.3574e-17
R5_11 36 38 26
C5_111 36 65 6.42888e-17
C5_112 38 65 6.42888e-17
R5_12 34 36 26
C5_121 34 65 6.42888e-17
C5_122 36 65 6.42888e-17
R5_13 39 41 26
C5_131 39 65 6.42888e-17
C5_132 41 65 6.42888e-17
R5_14 37 39 13
C5_141 37 65 5.3574e-17
C5_142 39 65 5.3574e-17
R5_15 35 37 26
C5_151 35 65 6.42888e-17
C5_152 37 65 6.42888e-17
R5_16 32 35 26
C5_161 32 65 6.42888e-17
C5_162 35 65 6.42888e-17
R4_1 45 44 7.5
R4_2 45 46 3.75
R2_1 52 53 15
R2_2 57 56 15
R2_3 62 60 15
R2_4 57 58 528
C2_41 57 65 9.34206e-17
C2_42 58 65 9.34206e-17
R2_5 54 57 432
C2_51 54 65 7.40922e-17
C2_52 57 65 7.40922e-17
R2_6 57 59 528
C2_61 57 65 9.34206e-17
C2_62 59 65 9.34206e-17
R2_7 55 57 432
C2_71 55 65 7.40922e-17
C2_72 57 65 7.40922e-17
R2_8 62 61 13
C2_81 62 65 4.28592e-17
C2_82 61 65 4.28592e-17
R2_9 56 61 78
C2_91 56 65 1.92866e-16
C2_92 61 65 1.92866e-16
R2_10 52 56 65
C2_101 52 65 1.60722e-16
C2_102 56 65 1.60722e-16
R1_1 69 68 15
R1_2 72 68 15
R1_3 73 70 15
R1_4 71 70 15
R1_5 67 66 15
R1_6 65 67 26
C1_61 65 65 6.42888e-17
C1_62 67 65 6.42888e-17
R1_7 71 73 26
C1_71 71 65 7.50036e-17
C1_72 73 65 7.50036e-17
R1_8 65 71 26
C1_81 65 65 6.42888e-17
C1_82 71 65 6.42888e-17
R1_9 69 72 26
C1_91 69 65 7.50036e-17
C1_92 72 65 7.50036e-17
R1_10 65 69 26
C1_101 65 65 6.42888e-17
C1_102 69 65 6.42888e-17
.ends oa22_x4
