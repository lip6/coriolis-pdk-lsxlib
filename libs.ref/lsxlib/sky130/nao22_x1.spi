* Spice description of nao22_x1
* Spice driver version 129702829
* Date ( dd/mm/yyyy hh:mm:ss ):  8/05/2026 at 14:22:52

* INTERF i0 i1 i2 nq vdd vss

.subckt nao22_x1 1 13 8 37 26 41
* NET 1 = i0
* NET 8 = i2
* NET 13 = i1
* NET 26 = vdd
* NET 37 = nq
* NET 41 = vss
Mtr_00006 23 9 38 26 sky130_fd_pr__pfet_01v8__model L=0.15U W=2.46U AS=0.7134P AD=0.7134P PS=5.5U PD=5.5U
Mtr_00005 19 4 22 26 sky130_fd_pr__pfet_01v8__model L=0.15U W=2.46U AS=0.7134P AD=0.7134P PS=5.5U PD=5.5U
Mtr_00004 38 16 19 26 sky130_fd_pr__pfet_01v8__model L=0.15U W=2.46U AS=0.7134P AD=0.7134P PS=5.5U PD=5.5U
Mtr_00003 29 2 35 41 sky130_fd_pr__nfet_01v8__model L=0.15U W=1.26U AS=0.3654P AD=0.3654P PS=3.1U PD=3.1U
Mtr_00002 35 14 31 41 sky130_fd_pr__nfet_01v8__model L=0.15U W=1.26U AS=0.3654P AD=0.3654P PS=3.1U PD=3.1U
Mtr_00001 31 7 42 41 sky130_fd_pr__nfet_01v8__model L=0.15U W=1.26U AS=0.3654P AD=0.3654P PS=3.1U PD=3.1U
R8_1 3 1 15
R8_2 3 4 576
C8_21 3 41 9.98634e-17
C8_22 4 41 9.98634e-17
R8_3 2 3 384
C8_31 2 41 6.76494e-17
C8_32 3 41 6.76494e-17
R7_1 10 8 15
R7_2 10 9 576
C7_21 10 41 9.98634e-17
C7_22 9 41 9.98634e-17
R7_3 7 10 384
C7_31 7 41 6.76494e-17
C7_32 10 41 6.76494e-17
R6_1 15 13 15
R6_2 15 16 576
C6_21 15 41 9.98634e-17
C6_22 16 41 9.98634e-17
R6_3 14 15 384
C6_31 14 41 6.76494e-17
C6_32 15 41 6.76494e-17
R4_1 25 23 15
R4_2 24 22 15
R4_3 24 26 26
C4_31 24 41 6.42888e-17
C4_32 26 41 6.42888e-17
R4_4 25 26 26
C4_41 25 41 6.42888e-17
C4_42 26 41 6.42888e-17
R3_1 32 31 15
R3_2 30 29 15
R3_3 30 32 52
C3_31 30 41 1.28578e-16
C3_32 32 41 1.28578e-16
R2_1 36 35 15
R2_2 37 38 3.75
R2_3 36 37 26
C2_31 36 41 6.42888e-17
C2_32 37 41 6.42888e-17
R1_1 43 42 15
R1_2 41 43 26
C1_21 41 41 6.42888e-17
C1_22 43 41 6.42888e-17
.ends nao22_x1
