* Spice description of zero_x0
* Spice driver version 722172845
* Date ( dd/mm/yyyy hh:mm:ss ):  8/05/2026 at 14:23:17

* INTERF nq vdd vss

.subckt zero_x0 8 4 11
* NET 4 = vdd
* NET 8 = nq
* NET 11 = vss
Mtr_00001 7 3 12 11 sky130_fd_pr__nfet_01v8__model L=0.15U W=0.42U AS=0.1218P AD=0.1218P PS=1.42U PD=1.42U
R3_1 2 1 15
R3_2 1 4 182
C3_21 1 11 4.17877e-16
C3_22 4 11 4.17877e-16
R3_3 2 3 96
C3_31 2 11 1.93284e-17
C3_32 3 11 1.93284e-17
R2_1 7 8 15
R1_1 12 13 15
R1_2 11 13 26
C1_21 11 11 6.42888e-17
C1_22 13 11 6.42888e-17
.ends zero_x0
