* Spice description of an12_x4
* Spice driver version 1574165421
* Date ( dd/mm/yyyy hh:mm:ss ):  8/05/2026 at 14:22:51

* INTERF i0 i1 q vdd vss

.subckt an12_x4 7 13 2 29 46
* NET 2 = q
* NET 7 = i0
* NET 13 = i1
* NET 29 = vdd
* NET 46 = vss
Mtr_00010 23 9 41 29 sky130_fd_pr__pfet_01v8__model L=0.15U W=1.02U AS=0.2958P AD=0.2958P PS=2.62U PD=2.62U
Mtr_00009 3 63 17 29 sky130_fd_pr__pfet_01v8__model L=0.15U W=2.46U AS=0.7134P AD=0.7134P PS=5.5U PD=5.5U
Mtr_00008 19 64 3 29 sky130_fd_pr__pfet_01v8__model L=0.15U W=2.46U AS=0.7134P AD=0.7134P PS=5.5U PD=5.5U
Mtr_00007 17 14 65 29 sky130_fd_pr__pfet_01v8__model L=0.15U W=1.26U AS=0.3654P AD=0.3654P PS=3.1U PD=3.1U
Mtr_00006 65 39 23 29 sky130_fd_pr__pfet_01v8__model L=0.15U W=1.26U AS=0.3654P AD=0.3654P PS=3.1U PD=3.1U
Mtr_00005 47 6 32 46 sky130_fd_pr__nfet_01v8__model L=0.15U W=0.54U AS=0.1566P AD=0.1566P PS=1.66U PD=1.66U
Mtr_00004 49 12 71 46 sky130_fd_pr__nfet_01v8__model L=0.15U W=1.26U AS=0.3654P AD=0.3654P PS=3.1U PD=3.1U
Mtr_00003 71 34 57 46 sky130_fd_pr__nfet_01v8__model L=0.15U W=1.26U AS=0.3654P AD=0.3654P PS=3.1U PD=3.1U
Mtr_00002 1 59 49 46 sky130_fd_pr__nfet_01v8__model L=0.15U W=1.26U AS=0.3654P AD=0.3654P PS=3.1U PD=3.1U
Mtr_00001 51 60 1 46 sky130_fd_pr__nfet_01v8__model L=0.15U W=1.26U AS=0.3654P AD=0.3654P PS=3.1U PD=3.1U
R8_1 2 1 7.5
R8_2 2 3 3.75
R7_1 8 7 15
R7_2 9 7 15
R7_3 6 8 48
C7_31 6 46 2.01449e-17
C7_32 8 46 2.01449e-17
R6_1 12 13 15
R6_2 14 13 15
R5_1 17 18 15
R5_2 27 17 15
R5_3 24 17 15
R5_4 21 17 15
R5_5 28 19 15
R5_6 22 19 15
R5_7 25 19 15
R5_8 20 19 15
R5_9 26 23 15
R5_10 26 29 26
C5_101 26 46 6.42888e-17
C5_102 29 46 6.42888e-17
R5_11 28 29 26
C5_111 28 46 6.42888e-17
C5_112 29 46 6.42888e-17
R5_12 25 28 13
C5_121 25 46 5.3574e-17
C5_122 28 46 5.3574e-17
R5_13 22 25 26
C5_131 22 46 6.42888e-17
C5_132 25 46 6.42888e-17
R5_14 20 22 26
C5_141 20 46 6.42888e-17
C5_142 22 46 6.42888e-17
R5_15 27 29 26
C5_151 27 46 6.42888e-17
C5_152 29 46 6.42888e-17
R5_16 24 27 13
C5_161 24 46 5.3574e-17
C5_162 27 46 5.3574e-17
R5_17 21 24 26
C5_171 21 46 6.42888e-17
C5_172 24 46 6.42888e-17
R5_18 18 21 26
C5_181 18 46 6.42888e-17
C5_182 21 46 6.42888e-17
R4_1 33 32 15
R4_2 38 37 15
R4_3 36 35 15
R4_4 43 41 15
R4_5 40 39 432
C4_51 40 46 7.40922e-17
C4_52 39 46 7.40922e-17
R4_6 36 34 528
C4_61 36 46 9.01992e-17
C4_62 34 46 9.01992e-17
R4_7 38 40 480
C4_71 38 46 8.37564e-17
C4_72 40 46 8.37564e-17
R4_8 42 43 13
C4_81 42 46 4.28592e-17
C4_82 43 46 4.28592e-17
R4_9 37 42 65
C4_91 37 46 1.60722e-16
C4_92 42 46 1.60722e-16
R4_10 35 37 52
C4_101 35 46 1.39292e-16
C4_102 37 46 1.39292e-16
R4_11 33 35 39
C4_111 33 46 1.07148e-16
C4_112 35 46 1.07148e-16
R3_1 53 49 15
R3_2 50 49 15
R3_3 54 51 15
R3_4 52 51 15
R3_5 48 47 15
R3_6 46 48 26
C3_61 46 46 6.42888e-17
C3_62 48 46 6.42888e-17
R3_7 52 54 26
C3_71 52 46 6.42888e-17
C3_72 54 46 6.42888e-17
R3_8 46 52 26
C3_81 46 46 6.42888e-17
C3_82 52 46 6.42888e-17
R3_9 50 53 26
C3_91 50 46 6.42888e-17
C3_92 53 46 6.42888e-17
R3_10 46 50 26
C3_101 46 46 6.42888e-17
C3_102 50 46 6.42888e-17
R2_1 58 57 15
R2_2 62 61 15
R2_3 67 65 15
R2_4 68 65 15
R2_5 62 63 480
C2_51 62 46 8.69778e-17
C2_52 63 46 8.69778e-17
R2_6 59 62 480
C2_61 59 46 8.0535e-17
C2_62 62 46 8.0535e-17
R2_7 62 64 480
C2_71 62 46 8.69778e-17
C2_72 64 46 8.69778e-17
R2_8 60 62 480
C2_81 60 46 8.0535e-17
C2_82 62 46 8.0535e-17
R2_9 67 68 13
C2_91 67 46 5.3574e-17
C2_92 68 46 5.3574e-17
R2_10 66 67 13
C2_101 66 46 4.28592e-17
C2_102 67 46 4.28592e-17
R2_11 61 66 78
C2_111 61 46 1.82152e-16
C2_112 66 46 1.82152e-16
R2_12 58 61 39
C2_121 58 46 9.64332e-17
C2_122 61 46 9.64332e-17
.ends an12_x4
