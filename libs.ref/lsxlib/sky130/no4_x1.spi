* Spice description of no4_x1
* Spice driver version 795114413
* Date ( dd/mm/yyyy hh:mm:ss ):  8/05/2026 at 14:22:51

* INTERF i0 i1 i2 i3 nq vdd vss

.subckt no4_x1 16 1 11 7 40 30 46
* NET 1 = i1
* NET 7 = i3
* NET 11 = i2
* NET 16 = i0
* NET 30 = vdd
* NET 40 = nq
* NET 46 = vss
Mtr_00008 33 18 41 30 sky130_fd_pr__pfet_01v8__model L=0.15U W=2.46U AS=0.7134P AD=0.7134P PS=5.5U PD=5.5U
Mtr_00007 27 8 21 30 sky130_fd_pr__pfet_01v8__model L=0.15U W=2.46U AS=0.7134P AD=0.7134P PS=5.5U PD=5.5U
Mtr_00006 21 13 24 30 sky130_fd_pr__pfet_01v8__model L=0.15U W=2.46U AS=0.7134P AD=0.7134P PS=5.5U PD=5.5U
Mtr_00005 24 3 33 30 sky130_fd_pr__pfet_01v8__model L=0.15U W=2.46U AS=0.7134P AD=0.7134P PS=5.5U PD=5.5U
Mtr_00004 36 2 49 46 sky130_fd_pr__nfet_01v8__model L=0.15U W=0.66U AS=0.1914P AD=0.1914P PS=1.9U PD=1.9U
Mtr_00003 39 6 51 46 sky130_fd_pr__nfet_01v8__model L=0.15U W=0.66U AS=0.1914P AD=0.1914P PS=1.9U PD=1.9U
Mtr_00002 49 12 39 46 sky130_fd_pr__nfet_01v8__model L=0.15U W=0.66U AS=0.1914P AD=0.1914P PS=1.9U PD=1.9U
Mtr_00001 47 17 36 46 sky130_fd_pr__nfet_01v8__model L=0.15U W=0.66U AS=0.1914P AD=0.1914P PS=1.9U PD=1.9U
R10_1 3 1 15
R10_2 2 3 1008
C10_21 2 46 1.75566e-16
C10_22 3 46 1.75566e-16
R9_1 8 7 15
R9_2 6 8 1008
C9_21 6 46 1.75566e-16
C9_22 8 46 1.75566e-16
R8_1 13 11 15
R8_2 12 13 1008
C8_21 12 46 1.75566e-16
C8_22 13 46 1.75566e-16
R7_1 18 16 15
R7_2 17 18 1008
C7_21 17 46 1.75566e-16
C7_22 18 46 1.75566e-16
R4_1 27 28 15
R4_2 27 29 15
R4_3 29 30 26
C4_31 29 46 6.42888e-17
C4_32 30 46 6.42888e-17
R4_4 28 29 13
C4_41 28 46 5.3574e-17
C4_42 29 46 5.3574e-17
R2_1 40 39 15
R2_2 42 41 15
R2_3 43 41 15
R2_4 38 36 15
R2_5 38 37 13
C2_51 38 46 5.3574e-17
C2_52 37 46 5.3574e-17
R2_6 43 42 13
C2_61 43 46 5.3574e-17
C2_62 42 46 5.3574e-17
R2_7 37 40 52
C2_71 37 46 1.28578e-16
C2_72 40 46 1.28578e-16
R2_8 42 40 78
C2_81 42 46 1.92866e-16
C2_82 40 46 1.92866e-16
R1_1 50 49 15
R1_2 52 51 15
R1_3 48 47 15
R1_4 46 48 26
C1_41 46 46 6.42888e-17
C1_42 48 46 6.42888e-17
R1_5 46 52 26
C1_51 46 46 6.42888e-17
C1_52 52 46 6.42888e-17
R1_6 46 50 26
C1_61 46 46 6.42888e-17
C1_62 50 46 6.42888e-17
.ends no4_x1
